$ Spice netlist generated by v2lvs
$ v2024.4_12.9    Tue Oct 1 20:33:59 PDT 2024
*.BUSDELIMITER [

.SUBCKT ActivationMultiplier_6_IN_WIDTH8_NUM_UNITS6_ACTIVATION_WIDTH8
+ activation[0][7] activation[0][6] activation[0][5] activation[0][4]
+ activation[0][3] activation[0][2] activation[0][1] activation[0][0]
+ activation[1][7] activation[1][6] activation[1][5] activation[1][4]
+ activation[1][3] activation[1][2] activation[1][1] activation[1][0]
+ activation[2][7] activation[2][6] activation[2][5] activation[2][4]
+ activation[2][3] activation[2][2] activation[2][1] activation[2][0]
+ activation[3][7] activation[3][6] activation[3][5] activation[3][4]
+ activation[3][3] activation[3][2] activation[3][1] activation[3][0]
+ activation[4][7] activation[4][6] activation[4][5] activation[4][4]
+ activation[4][3] activation[4][2] activation[4][1] activation[4][0]
+ activation[5][7] activation[5][6] activation[5][5] activation[5][4]
+ activation[5][3] activation[5][2] activation[5][1] activation[5][0]
+ weight[0][7] weight[0][6] weight[0][5] weight[0][4] weight[0][3] weight[0][2]
+ weight[0][1] weight[0][0] weight[1][7] weight[1][6] weight[1][5] weight[1][4]
+ weight[1][3] weight[1][2] weight[1][1] weight[1][0] weight[2][7] weight[2][6]
+ weight[2][5] weight[2][4] weight[2][3] weight[2][2] weight[2][1] weight[2][0]
+ weight[3][7] weight[3][6] weight[3][5] weight[3][4] weight[3][3] weight[3][2]
+ weight[3][1] weight[3][0] weight[4][7] weight[4][6] weight[4][5] weight[4][4]
+ weight[4][3] weight[4][2] weight[4][1] weight[4][0] weight[5][7] weight[5][6]
+ weight[5][5] weight[5][4] weight[5][3] weight[5][2] weight[5][1] weight[5][0]
+ clk rst start result[0][7] result[0][6] result[0][5] result[0][4]
+ result[0][3] result[0][2] result[0][1] result[0][0] result[1][7] result[1][6]
+ result[1][5] result[1][4] result[1][3] result[1][2] result[1][1] result[1][0]
+ result[2][7] result[2][6] result[2][5] result[2][4] result[2][3] result[2][2]
+ result[2][1] result[2][0] result[3][7] result[3][6] result[3][5] result[3][4]
+ result[3][3] result[3][2] result[3][1] result[3][0] result[4][7] result[4][6]
+ result[4][5] result[4][4] result[4][3] result[4][2] result[4][1] result[4][0]
+ result[5][7] result[5][6] result[5][5] result[5][4] result[5][3] result[5][2]
+ result[5][1] result[5][0] en DFT_/sdi DFT_/sen n_0 SPCASCAN_N1 p_1
+ SPCASCAN_N2 SPCASCAN_N3 n_3 SPCASCAN_N5
*.CONNECT result[5][5] VSS
*.CONNECT result[5][6] VSS
*.CONNECT result[5][7] VSS
*.CONNECT result[4][5] VSS
*.CONNECT result[4][6] VSS
*.CONNECT result[4][7] VSS
*.CONNECT result[3][5] VSS
*.CONNECT result[3][6] VSS
*.CONNECT result[3][7] VSS
*.CONNECT result[2][5] VSS
*.CONNECT result[2][6] VSS
*.CONNECT result[2][7] VSS
*.CONNECT result[1][5] VSS
*.CONNECT result[1][6] VSS
*.CONNECT result[1][7] VSS
*.CONNECT result[0][5] VSS
*.CONNECT result[0][6] VSS
*.CONNECT result[0][7] VSS
XFE_OFC4_n_180 BUJIX1 $PINS Q=FE_OFN5_n_180 A=n_180
XFE_OFC0_scan_en BUJIX1 $PINS Q=FE_OFN1_scan_en A=DFT_/sen
XFE_RC_0_0 NA3I1JIX0 $PINS Q=n_135 AN=n_190 B=cycle_counter[3]
+ C=cycle_counter[0]
XFE_DBTC0_n_54 INVJIX1 $PINS Q=FE_DBTN0_n_54 A=n_54
XAM_INST[0].am ActivationMultiplier_IN_WIDTH8 $PINS weight[7]=weight[0][7]
+ weight[6]=weight[0][6] weight[5]=weight[0][5] weight[4]=weight[0][4]
+ weight[3]=weight[0][3] weight[2]=weight[0][2] weight[1]=weight[0][1]
+ weight[0]=weight[0][0] activation=n_184 en=en result[7]=am_result[0][7]
+ result[6]=am_result[0][6] result[5]=am_result[0][5] result[4]=am_result[0][4]
+ result[3]=am_result[0][3] result[2]=am_result[0][2] result[1]=am_result[0][1]
+ result[0]=am_result[0][0]
XAM_INST[1].am ActivationMultiplier_IN_WIDTH8 $PINS weight[7]=weight[1][7]
+ weight[6]=weight[1][6] weight[5]=weight[1][5] weight[4]=weight[1][4]
+ weight[3]=weight[1][3] weight[2]=weight[1][2] weight[1]=weight[1][1]
+ weight[0]=weight[1][0] activation=n_188 en=en result[7]=am_result[1][7]
+ result[6]=am_result[1][6] result[5]=am_result[1][5] result[4]=am_result[1][4]
+ result[3]=am_result[1][3] result[2]=am_result[1][2] result[1]=am_result[1][1]
+ result[0]=am_result[1][0]
XAM_INST[2].am ActivationMultiplier_IN_WIDTH8 $PINS weight[7]=weight[2][7]
+ weight[6]=weight[2][6] weight[5]=weight[2][5] weight[4]=weight[2][4]
+ weight[3]=weight[2][3] weight[2]=weight[2][2] weight[1]=weight[2][1]
+ weight[0]=weight[2][0] activation=n_187 en=en result[7]=am_result[2][7]
+ result[6]=am_result[2][6] result[5]=am_result[2][5] result[4]=am_result[2][4]
+ result[3]=am_result[2][3] result[2]=am_result[2][2] result[1]=am_result[2][1]
+ result[0]=am_result[2][0]
XAM_INST[3].am ActivationMultiplier_IN_WIDTH8 $PINS weight[7]=weight[3][7]
+ weight[6]=weight[3][6] weight[5]=weight[3][5] weight[4]=weight[3][4]
+ weight[3]=weight[3][3] weight[2]=weight[3][2] weight[1]=weight[3][1]
+ weight[0]=weight[3][0] activation=n_186 en=en result[7]=am_result[3][7]
+ result[6]=am_result[3][6] result[5]=am_result[3][5] result[4]=am_result[3][4]
+ result[3]=am_result[3][3] result[2]=am_result[3][2] result[1]=am_result[3][1]
+ result[0]=am_result[3][0]
XAM_INST[4].am ActivationMultiplier_IN_WIDTH8 $PINS weight[7]=weight[4][7]
+ weight[6]=weight[4][6] weight[5]=weight[4][5] weight[4]=weight[4][4]
+ weight[3]=weight[4][3] weight[2]=weight[4][2] weight[1]=weight[4][1]
+ weight[0]=weight[4][0] activation=n_185 en=en result[7]=am_result[4][7]
+ result[6]=am_result[4][6] result[5]=am_result[4][5] result[4]=am_result[4][4]
+ result[3]=am_result[4][3] result[2]=am_result[4][2] result[1]=am_result[4][1]
+ result[0]=am_result[4][0]
XAM_INST[5].am ActivationMultiplier_IN_WIDTH8 $PINS weight[7]=weight[5][7]
+ weight[6]=weight[5][6] weight[5]=weight[5][5] weight[4]=weight[5][4]
+ weight[3]=weight[5][3] weight[2]=weight[5][2] weight[1]=weight[5][1]
+ weight[0]=weight[5][0] activation=n_189 en=en result[7]=am_result[5][7]
+ result[6]=am_result[5][6] result[5]=am_result[5][5] result[4]=am_result[5][4]
+ result[3]=am_result[5][3] result[2]=am_result[5][2] result[1]=am_result[5][1]
+ result[0]=am_result[5][0]
Xg2406 INVJIX1 $PINS Q=n_180 A=rst
Xg3309__2398 NA4JIX0 $PINS Q=n_184 A=n_169 B=n_171 C=n_165 D=n_160
Xg3310__5107 NA4JIX0 $PINS Q=n_185 A=n_167 B=n_163 C=n_179 D=n_157
Xg3311__6260 NA4JIX0 $PINS Q=n_186 A=n_172 B=n_175 C=n_177 D=n_159
Xg3312__4319 NA4JIX0 $PINS Q=n_189 A=n_173 B=n_176 C=n_174 D=n_161
Xg3313__8428 NA4JIX0 $PINS Q=n_187 A=n_168 B=n_162 C=n_166 D=n_158
Xg3314__5526 NA4JIX0 $PINS Q=n_188 A=n_164 B=n_178 C=n_170 D=n_156
Xg3315__6783 AN22JIX0 $PINS Q=n_179 A=n_151 B=activation_reg[4][1] C=n_147
+ D=activation_reg[4][0]
Xg3316__3680 AN22JIX0 $PINS Q=n_178 A=n_152 B=activation_reg[1][7] C=n_155
+ D=activation_reg[1][3]
Xg3317__1617 AN22JIX0 $PINS Q=n_177 A=n_151 B=activation_reg[3][1] C=n_147
+ D=activation_reg[3][0]
Xg3318__2802 AN22JIX0 $PINS Q=n_176 A=n_152 B=activation_reg[5][7] C=n_155
+ D=activation_reg[5][3]
Xg3319__1705 AN22JIX0 $PINS Q=n_175 A=n_152 B=activation_reg[3][7] C=n_155
+ D=activation_reg[3][3]
Xg3320__5122 AN22JIX0 $PINS Q=n_174 A=n_151 B=activation_reg[5][1] C=n_147
+ D=activation_reg[5][0]
Xg3321__8246 AN22JIX0 $PINS Q=n_173 A=n_153 B=activation_reg[5][6] C=n_154
+ D=activation_reg[5][2]
Xg3322__7098 AN22JIX0 $PINS Q=n_172 A=n_153 B=activation_reg[3][6] C=n_154
+ D=activation_reg[3][2]
Xg3323__6131 AN22JIX0 $PINS Q=n_171 A=n_152 B=activation_reg[0][7] C=n_155
+ D=activation_reg[0][3]
Xg3324__1881 AN22JIX0 $PINS Q=n_170 A=n_151 B=activation_reg[1][1] C=n_147
+ D=activation_reg[1][0]
Xg3325__5115 AN22JIX0 $PINS Q=n_169 A=n_153 B=activation_reg[0][6] C=n_154
+ D=activation_reg[0][2]
Xg3326__7482 AN22JIX0 $PINS Q=n_168 A=n_153 B=activation_reg[2][6] C=n_154
+ D=activation_reg[2][2]
Xg3327__4733 AN22JIX0 $PINS Q=n_167 A=n_153 B=activation_reg[4][6] C=n_154
+ D=activation_reg[4][2]
Xg3328__6161 AN22JIX0 $PINS Q=n_166 A=n_151 B=activation_reg[2][1] C=n_147
+ D=activation_reg[2][0]
Xg3329__9315 AN22JIX0 $PINS Q=n_165 A=n_151 B=activation_reg[0][1] C=n_147
+ D=activation_reg[0][0]
Xg3330__9945 AN22JIX0 $PINS Q=n_164 A=n_153 B=activation_reg[1][6] C=n_154
+ D=activation_reg[1][2]
Xg3331__2883 AN22JIX0 $PINS Q=n_163 A=n_152 B=activation_reg[4][7] C=n_155
+ D=activation_reg[4][3]
Xg3332__2346 AN22JIX0 $PINS Q=n_162 A=n_152 B=activation_reg[2][7] C=n_155
+ D=activation_reg[2][3]
Xg3333__1666 AN22JIX0 $PINS Q=n_161 A=n_149 B=activation_reg[5][5] C=n_146
+ D=activation_reg[5][4]
Xg3334__7410 AN22JIX0 $PINS Q=n_160 A=n_149 B=activation_reg[0][5] C=n_146
+ D=activation_reg[0][4]
Xg3335__6417 AN22JIX0 $PINS Q=n_159 A=n_149 B=activation_reg[3][5] C=n_146
+ D=activation_reg[3][4]
Xg3336__5477 AN22JIX0 $PINS Q=n_158 A=n_149 B=activation_reg[2][5] C=n_146
+ D=activation_reg[2][4]
Xg3337__2398 AN22JIX0 $PINS Q=n_157 A=n_149 B=activation_reg[4][5] C=n_146
+ D=activation_reg[4][4]
Xg3338__5107 AN22JIX0 $PINS Q=n_156 A=n_149 B=activation_reg[1][5] C=n_146
+ D=activation_reg[1][4]
Xg3339__6260 AND2JIX0 $PINS Q=n_155 A=n_150 B=cycle_counter[2]
Xg3340__4319 AND2JIX0 $PINS Q=n_154 A=n_148 B=cycle_counter[2]
Xg3341__8428 NO2I1JIX0 $PINS Q=n_153 AN=n_148 B=cycle_counter[2]
Xg3342__5526 NO2I1JIX0 $PINS Q=n_152 AN=n_150 B=cycle_counter[2]
Xg3343__6783 AND3JIX0 $PINS Q=n_151 A=n_144 B=cycle_counter[2]
+ C=cycle_counter[1]
Xg3344__3680 NO2I1JIX0 $PINS Q=n_150 AN=n_144 B=cycle_counter[1]
Xg3345__1617 NO2I1JIX0 $PINS Q=n_149 AN=n_144 B=n_190
Xg3346 INVJIX0 $PINS Q=n_147 A=n_192
Xg3347 INVJIX0 $PINS Q=n_191 A=n_146
Xg3348__2802 NO2JIX0 $PINS Q=n_148 A=n_145 B=cycle_counter[1]
Xg3350__1705 NO2JIX0 $PINS Q=n_146 A=n_145 B=n_190
Xg3352__5122 NA2I1JIX0 $PINS Q=n_145 AN=cycle_counter[3] B=cycle_counter[0]
Xg3353__8246 NO2JIX0 $PINS Q=n_144 A=cycle_counter[3] B=cycle_counter[0]
Xg3354__7098 NA2I1JIX0 $PINS Q=n_190 AN=cycle_counter[2] B=cycle_counter[1]
Xg2__6131 NA3I1JIX0 $PINS Q=n_192 AN=n_145 B=cycle_counter[1]
+ C=cycle_counter[2]
Xactivation_reg_reg[0][0] SDFRRQJIX1 $PINS Q=activation_reg[0][0] C=clk D=n_104
+ RN=FE_OFN5_n_180 SD=activation_reg[1][2] SE=FE_OFN1_scan_en
Xactivation_reg_reg[0][1] SDFRRQJIX1 $PINS Q=activation_reg[0][1] C=clk D=n_109
+ RN=FE_OFN5_n_180 SD=activation_reg[0][5] SE=FE_OFN1_scan_en
Xactivation_reg_reg[0][2] SDFRRQJIX1 $PINS Q=activation_reg[0][2] C=clk D=n_107
+ RN=FE_OFN5_n_180 SD=activation_reg[0][3] SE=FE_OFN1_scan_en
Xactivation_reg_reg[0][3] SDFRRQJIX1 $PINS Q=activation_reg[0][3] C=clk D=n_106
+ RN=FE_OFN5_n_180 SD=activation_reg[0][4] SE=FE_OFN1_scan_en
Xactivation_reg_reg[0][4] SDFRRQJIX1 $PINS Q=activation_reg[0][4] C=clk D=n_105
+ RN=FE_OFN5_n_180 SD=activation_reg[0][1] SE=FE_OFN1_scan_en
Xactivation_reg_reg[0][5] SDFRRQJIX1 $PINS Q=activation_reg[0][5] C=clk D=n_103
+ RN=FE_OFN5_n_180 SD=activation_reg[1][0] SE=FE_OFN1_scan_en
Xactivation_reg_reg[0][6] SDFRRQJIX1 $PINS Q=activation_reg[0][6] C=clk D=n_100
+ RN=FE_OFN5_n_180 SD=activation_reg[0][2] SE=FE_OFN1_scan_en
Xactivation_reg_reg[0][7] SDFRRQJIX1 $PINS Q=activation_reg[0][7] C=clk D=n_102
+ RN=FE_OFN5_n_180 SD=activation_reg[0][6] SE=FE_OFN1_scan_en
Xactivation_reg_reg[1][0] SDFRRQJIX1 $PINS Q=activation_reg[1][0] C=clk D=n_101
+ RN=FE_OFN5_n_180 SD=activation_reg[1][1] SE=FE_OFN1_scan_en
Xactivation_reg_reg[1][1] SDFRRQJIX1 $PINS Q=activation_reg[1][1] C=clk D=n_99
+ RN=FE_OFN5_n_180 SD=activation_reg[0][0] SE=FE_OFN1_scan_en
Xactivation_reg_reg[1][2] SDFRRQJIX1 $PINS Q=activation_reg[1][2] C=clk D=n_98
+ RN=FE_OFN5_n_180 SD=activation_reg[1][3] SE=FE_OFN1_scan_en
Xactivation_reg_reg[1][3] SDFRRQJIX1 $PINS Q=activation_reg[1][3] C=clk D=n_97
+ RN=FE_OFN5_n_180 SD=activation_reg[1][5] SE=FE_OFN1_scan_en
Xactivation_reg_reg[1][4] SDFRRQJIX1 $PINS Q=activation_reg[1][4] C=clk D=n_96
+ RN=FE_OFN5_n_180 SD=n_13 SE=FE_OFN1_scan_en
Xactivation_reg_reg[1][5] SDFRRQJIX1 $PINS Q=activation_reg[1][5] C=clk D=n_95
+ RN=FE_OFN5_n_180 SD=activation_reg[1][7] SE=FE_OFN1_scan_en
Xactivation_reg_reg[1][6] SDFRRQJIX1 $PINS Q=activation_reg[1][6] C=clk D=n_94
+ RN=FE_OFN5_n_180 SD=activation_reg[1][4] SE=FE_OFN1_scan_en
Xactivation_reg_reg[1][7] SDFRRQJIX1 $PINS Q=activation_reg[1][7] C=clk D=n_93
+ RN=FE_OFN5_n_180 SD=activation_reg[2][2] SE=FE_OFN1_scan_en
Xactivation_reg_reg[2][0] SDFRRQJIX1 $PINS Q=activation_reg[2][0] C=clk D=n_92
+ RN=FE_OFN5_n_180 SD=activation_reg[1][6] SE=FE_OFN1_scan_en
Xactivation_reg_reg[2][1] SDFRRQJIX1 $PINS Q=activation_reg[2][1] C=clk D=n_91
+ RN=FE_OFN5_n_180 SD=activation_reg[2][0] SE=FE_OFN1_scan_en
Xactivation_reg_reg[2][2] SDFRRQJIX1 $PINS Q=activation_reg[2][2] C=clk D=n_90
+ RN=FE_OFN5_n_180 SD=n_16 SE=FE_OFN1_scan_en
Xactivation_reg_reg[2][3] SDFRRQJIX1 $PINS Q=activation_reg[2][3] C=clk D=n_89
+ RN=FE_OFN5_n_180 SD=activation_reg[3][0] SE=FE_OFN1_scan_en
Xactivation_reg_reg[2][4] SDFRRQJIX1 $PINS Q=activation_reg[2][4] C=clk D=n_88
+ RN=FE_OFN5_n_180 SD=activation_reg[2][1] SE=FE_OFN1_scan_en
Xactivation_reg_reg[2][5] SDFRRQJIX1 $PINS Q=activation_reg[2][5] C=clk D=n_87
+ RN=FE_OFN5_n_180 SD=activation_reg[2][4] SE=FE_OFN1_scan_en
Xactivation_reg_reg[2][6] SDFRRQJIX1 $PINS Q=activation_reg[2][6] C=clk D=n_132
+ RN=FE_OFN5_n_180 SD=activation_reg[2][3] SE=FE_OFN1_scan_en
Xactivation_reg_reg[2][7] SDFRRQJIX1 $PINS Q=activation_reg[2][7] C=clk D=n_134
+ RN=FE_OFN5_n_180 SD=activation_reg[2][5] SE=FE_OFN1_scan_en
Xactivation_reg_reg[3][0] SDFRRQJIX1 $PINS Q=activation_reg[3][0] C=clk D=n_133
+ RN=FE_OFN5_n_180 SD=activation_reg[2][7] SE=FE_OFN1_scan_en
Xactivation_reg_reg[3][1] SDFRRQJIX1 $PINS Q=activation_reg[3][1] C=clk D=n_131
+ RN=FE_OFN5_n_180 SD=activation_reg[3][4] SE=FE_OFN1_scan_en
Xactivation_reg_reg[3][2] SDFRRQJIX1 $PINS Q=activation_reg[3][2] C=clk D=n_130
+ RN=FE_OFN5_n_180 SD=activation_reg[3][1] SE=DFT_/sen
Xactivation_reg_reg[3][3] SDFRRQJIX1 $PINS Q=activation_reg[3][3] C=clk D=n_129
+ RN=FE_OFN5_n_180 SD=activation_reg[3][6] SE=DFT_/sen
Xactivation_reg_reg[3][4] SDFRRQJIX1 $PINS Q=activation_reg[3][4] C=clk D=n_136
+ RN=FE_OFN5_n_180 SD=activation_reg[3][5] SE=FE_OFN1_scan_en
Xactivation_reg_reg[3][5] SDFRRQJIX1 $PINS Q=activation_reg[3][5] C=clk D=n_127
+ RN=FE_OFN5_n_180 SD=DFT_/sdi SE=DFT_/sen
Xactivation_reg_reg[3][6] SDFRRQJIX1 $PINS Q=activation_reg[3][6] C=clk D=n_126
+ RN=FE_OFN5_n_180 SD=activation_reg[3][2] SE=DFT_/sen
Xactivation_reg_reg[3][7] SDFRRQJIX1 $PINS Q=activation_reg[3][7] C=clk D=n_125
+ RN=FE_OFN5_n_180 SD=activation_reg[4][1] SE=DFT_/sen
Xactivation_reg_reg[4][0] SDFRRQJIX1 $PINS Q=activation_reg[4][0] C=clk D=n_124
+ RN=FE_OFN5_n_180 SD=activation_reg[3][7] SE=DFT_/sen
Xactivation_reg_reg[4][1] SDFRRQJIX1 $PINS Q=activation_reg[4][1] C=clk D=n_123
+ RN=FE_OFN5_n_180 SD=activation_reg[3][3] SE=DFT_/sen
Xactivation_reg_reg[4][2] SDFRRQJIX1 $PINS Q=activation_reg[4][2] C=clk D=n_122
+ RN=FE_OFN5_n_180 SD=activation_reg[4][7] SE=DFT_/sen
Xactivation_reg_reg[4][3] SDFRRQJIX1 $PINS Q=activation_reg[4][3] C=clk D=n_121
+ RN=FE_OFN5_n_180 SD=activation_reg[4][6] SE=DFT_/sen
Xactivation_reg_reg[4][4] SDFRRQJIX1 $PINS Q=activation_reg[4][4] C=clk D=n_120
+ RN=FE_OFN5_n_180 SD=cycle_counter[1] SE=DFT_/sen
Xactivation_reg_reg[4][5] SDFRRQJIX1 $PINS Q=activation_reg[4][5] C=clk D=n_119
+ RN=FE_OFN5_n_180 SD=activation_reg[4][4] SE=DFT_/sen
Xactivation_reg_reg[4][6] SDFRRQJIX1 $PINS Q=activation_reg[4][6] C=clk D=n_118
+ RN=FE_OFN5_n_180 SD=activation_reg[4][2] SE=DFT_/sen
Xactivation_reg_reg[4][7] SDFRRQJIX1 $PINS Q=activation_reg[4][7] C=clk D=n_117
+ RN=FE_OFN5_n_180 SD=activation_reg[4][5] SE=DFT_/sen
Xactivation_reg_reg[5][0] SDFRRQJIX1 $PINS Q=activation_reg[5][0] C=clk D=n_116
+ RN=FE_OFN5_n_180 SD=activation_reg[5][1] SE=DFT_/sen
Xactivation_reg_reg[5][1] SDFRRQJIX1 $PINS Q=activation_reg[5][1] C=clk D=n_115
+ RN=FE_OFN5_n_180 SD=n_8 SE=DFT_/sen
Xactivation_reg_reg[5][2] SDFRRQJIX1 $PINS Q=activation_reg[5][2] C=clk D=n_114
+ RN=FE_OFN5_n_180 SD=activation_reg[5][0] SE=DFT_/sen
Xactivation_reg_reg[5][3] SDFRRQJIX1 $PINS Q=activation_reg[5][3] C=clk D=n_113
+ RN=FE_OFN5_n_180 SD=activation_reg[5][2] SE=DFT_/sen
Xactivation_reg_reg[5][4] SDFRRQJIX1 $PINS Q=activation_reg[5][4] C=clk D=n_112
+ RN=FE_OFN5_n_180 SD=activation_reg[5][5] SE=DFT_/sen
Xactivation_reg_reg[5][5] SDFRRQJIX1 $PINS Q=activation_reg[5][5] C=clk D=n_111
+ RN=FE_OFN5_n_180 SD=activation_reg[5][6] SE=DFT_/sen
Xactivation_reg_reg[5][6] SDFRRQJIX1 $PINS Q=activation_reg[5][6] C=clk D=n_110
+ RN=FE_OFN5_n_180 SD=activation_reg[5][7] SE=DFT_/sen
Xactivation_reg_reg[5][7] SDFRRQJIX1 $PINS Q=activation_reg[5][7] C=clk D=n_108
+ RN=FE_OFN5_n_180 SD=activation_reg[5][3] SE=DFT_/sen
Xcycle_counter_reg[0] SDFRRQJIX1 $PINS Q=cycle_counter[0] C=clk D=n_128
+ RN=FE_OFN5_n_180 SD=activation_reg[4][0] SE=FE_OFN1_scan_en
Xcycle_counter_reg[1] SDFRRQJIX1 $PINS Q=cycle_counter[1] C=clk D=n_140
+ RN=FE_OFN5_n_180 SD=cycle_counter[0] SE=FE_OFN1_scan_en
Xcycle_counter_reg[2] SDFRRQJIX1 $PINS Q=cycle_counter[2] C=clk D=n_142
+ RN=FE_OFN5_n_180 SD=activation_reg[2][6] SE=FE_OFN1_scan_en
Xcycle_counter_reg[3] SDFRRQJIX1 $PINS Q=cycle_counter[3] C=clk D=n_141
+ RN=FE_OFN5_n_180 SD=activation_reg[4][3] SE=FE_OFN1_scan_en
Xen_reg SDFRRQJIX1 $PINS Q=en C=clk D=n_143 RN=FE_OFN5_n_180
+ SD=cycle_counter[2] SE=FE_OFN1_scan_en
Xresult_reg[0][0] SDFRRSJIX1 $PINS Q=result[0][0] QN=n_17 C=clk D=n_75
+ RN=FE_OFN5_n_180 SD=cycle_counter[3] SE=FE_OFN1_scan_en SN=VDD
Xresult_reg[0][1] SDFRRSJIX1 $PINS Q=result[0][1] QN=n_16 C=clk D=n_74
+ RN=FE_OFN5_n_180 SD=en SE=FE_OFN1_scan_en SN=VDD
Xresult_reg[0][2] SDFRRSJIX1 $PINS Q=result[0][2] QN=n_15 C=clk D=n_79
+ RN=FE_OFN5_n_180 SD=activation_reg[0][7] SE=FE_OFN1_scan_en SN=VDD
Xresult_reg[0][3] SDFRRQJIX1 $PINS Q=result[0][3] C=clk D=n_73 RN=FE_OFN5_n_180
+ SD=n_15 SE=FE_OFN1_scan_en
Xresult_reg[0][4] SDFRRQJIX1 $PINS Q=result[0][4] C=clk D=n_72 RN=FE_OFN5_n_180
+ SD=result[1][4] SE=FE_OFN1_scan_en
Xresult_reg[1][0] SDFRRSJIX1 $PINS Q=result[1][0] QN=n_14 C=clk D=n_78
+ RN=FE_OFN5_n_180 SD=n_17 SE=FE_OFN1_scan_en SN=VDD
Xresult_reg[1][1] SDFRRSJIX1 $PINS Q=result[1][1] QN=n_13 C=clk D=n_56
+ RN=FE_OFN5_n_180 SD=n_9 SE=FE_OFN1_scan_en SN=VDD
Xresult_reg[1][2] SDFRRSJIX1 $PINS Q=result[1][2] QN=n_12 C=clk D=n_70
+ RN=FE_OFN5_n_180 SD=n_10 SE=FE_OFN1_scan_en SN=VDD
Xresult_reg[1][3] SDFRRQJIX1 $PINS Q=result[1][3] C=clk D=n_64 RN=FE_OFN5_n_180
+ SD=result[0][3] SE=FE_OFN1_scan_en
Xresult_reg[1][4] SDFRRQJIX1 $PINS Q=result[1][4] C=clk D=n_69 RN=FE_OFN5_n_180
+ SD=result[3][3] SE=FE_OFN1_scan_en
Xresult_reg[2][0] SDFRRSJIX1 $PINS Q=result[2][0] QN=n_11 C=clk D=n_57
+ RN=FE_OFN5_n_180 SD=n_14 SE=DFT_/sen SN=VDD
Xresult_reg[2][1] SDFRRSJIX1 $PINS Q=result[2][1] QN=n_10 C=clk D=n_67
+ RN=FE_OFN5_n_180 SD=n_7 SE=FE_OFN1_scan_en SN=VDD
Xresult_reg[2][2] SDFRRSJIX1 $PINS Q=result[2][2] QN=n_9 C=clk D=n_66
+ RN=FE_OFN5_n_180 SD=n_6 SE=FE_OFN1_scan_en SN=VDD
Xresult_reg[2][3] SDFRRQJIX1 $PINS Q=result[2][3] C=clk D=n_65 RN=FE_OFN5_n_180
+ SD=result[1][3] SE=FE_OFN1_scan_en
Xresult_reg[2][4] SDFRRQJIX1 $PINS Q=result[2][4] C=clk D=n_68 RN=FE_OFN5_n_180
+ SD=result[0][4] SE=FE_OFN1_scan_en
Xresult_reg[3][0] SDFRRSJIX1 $PINS Q=result[3][0] QN=n_8 C=clk D=n_63
+ RN=FE_OFN5_n_180 SD=n_11 SE=DFT_/sen SN=VDD
Xresult_reg[3][1] SDFRRSJIX1 $PINS Q=result[3][1] QN=n_7 C=clk D=n_61
+ RN=FE_OFN5_n_180 SD=p_1 SE=FE_OFN1_scan_en SN=VDD
Xresult_reg[3][2] SDFRRSJIX1 $PINS Q=result[3][2] QN=n_6 C=clk D=n_59
+ RN=FE_OFN5_n_180 SD=n_12 SE=FE_OFN1_scan_en SN=VDD
Xresult_reg[3][3] SDFRRQJIX1 $PINS Q=result[3][3] C=clk D=n_62 RN=FE_OFN5_n_180
+ SD=result[2][3] SE=FE_OFN1_scan_en
Xresult_reg[3][4] SDFRRQJIX1 $PINS Q=result[3][4] C=clk D=n_60 RN=FE_OFN5_n_180
+ SD=result[2][4] SE=FE_OFN1_scan_en
Xresult_reg[4][0] SDFRRSJIX1 $PINS Q=result[4][0] QN=n_5 C=clk D=n_80
+ RN=FE_OFN5_n_180 SD=n_2 SE=DFT_/sen SN=VDD
Xresult_reg[4][1] SDFRRSJIX1 $PINS Q=result[4][1] QN=n_4 C=clk D=n_85 RN=n_180
+ SD=n_1 SE=DFT_/sen SN=VDD
Xresult_reg[4][2] SDFRRSJIX1 $PINS Q=result[4][2] QN=n_3 C=clk D=n_77 RN=n_180
+ SD=n_4 SE=DFT_/sen SN=VDD
Xresult_reg[4][3] SDFRRQJIX1 $PINS Q=result[4][3] C=clk D=n_58 RN=n_180
+ SD=result[5][3] SE=DFT_/sen
Xresult_reg[4][4] SDFRRQJIX1 $PINS Q=result[4][4] C=clk D=n_81 RN=n_180
+ SD=result[4][3] SE=DFT_/sen
Xresult_reg[5][0] SDFRRSJIX1 $PINS Q=result[5][0] QN=n_2 C=clk D=n_83
+ RN=FE_OFN5_n_180 SD=activation_reg[5][4] SE=DFT_/sen SN=VDD
Xresult_reg[5][1] SDFRRSJIX1 $PINS Q=result[5][1] QN=n_1 C=clk D=n_82 RN=n_180
+ SD=n_5 SE=DFT_/sen SN=VDD
Xresult_reg[5][2] SDFRRSJIX1 $PINS Q=result[5][2] QN=n_0 C=clk D=n_71 RN=n_180
+ SD=SPCASCAN_N5 SE=DFT_/sen SN=VDD
Xresult_reg[5][3] SDFRRQJIX1 $PINS Q=result[5][3] C=clk D=n_84 RN=n_180 SD=n_0
+ SE=DFT_/sen
Xresult_reg[5][4] SDFRRQJIX1 $PINS Q=result[5][4] C=clk D=n_76 RN=n_180
+ SD=result[4][4] SE=DFT_/sen
Xg3409__1881 AO21JIX0 $PINS Q=n_143 A=n_135 B=en C=n_54
Xg3411__5115 ON21JIX0 $PINS Q=n_142 A=n_191 B=n_47 C=n_139
Xg3412__7482 ON21JIX0 $PINS Q=n_141 A=n_192 B=n_47 C=n_138
Xg3439__4733 AO32JIX0 $PINS Q=n_140 A=en B=cycle_counter[0] C=n_49
+ D=cycle_counter[1] E=n_86
Xg3440__6161 NA2JIX0 $PINS Q=n_139 A=n_137 B=cycle_counter[2]
Xg3441__9315 NA2JIX0 $PINS Q=n_138 A=n_137 B=cycle_counter[3]
Xg3465__9945 AO22JIX0 $PINS Q=n_136 A=n_54 B=activation[3][4] C=FE_DBTN0_n_54
+ D=activation_reg[3][4]
Xg3467__2346 AO22JIX0 $PINS Q=n_134 A=n_54 B=activation[2][7] C=FE_DBTN0_n_54
+ D=activation_reg[2][7]
Xg3468__1666 AO22JIX0 $PINS Q=n_133 A=n_54 B=activation[3][0] C=FE_DBTN0_n_54
+ D=activation_reg[3][0]
Xg3469__7410 AO22JIX0 $PINS Q=n_132 A=n_54 B=activation[2][6] C=FE_DBTN0_n_54
+ D=activation_reg[2][6]
Xg3470__6417 AO22JIX0 $PINS Q=n_131 A=n_54 B=activation[3][1] C=FE_DBTN0_n_54
+ D=activation_reg[3][1]
Xg3471__5477 AO22JIX0 $PINS Q=n_130 A=n_54 B=activation[3][2] C=FE_DBTN0_n_54
+ D=activation_reg[3][2]
Xg3472__2398 AO22JIX0 $PINS Q=n_129 A=n_54 B=activation[3][3] C=FE_DBTN0_n_54
+ D=activation_reg[3][3]
Xg3473__5107 ON31JIX0 $PINS Q=n_128 A=start B=en C=n_48 D=n_55
Xg3495__6260 AO21JIX0 $PINS Q=n_137 A=n_49 B=en C=n_86
Xg3505__4319 AO22JIX0 $PINS Q=n_127 A=n_54 B=activation[3][5] C=FE_DBTN0_n_54
+ D=activation_reg[3][5]
Xg3506__8428 AO22JIX0 $PINS Q=n_126 A=n_54 B=activation[3][6] C=FE_DBTN0_n_54
+ D=activation_reg[3][6]
Xg3507__5526 AO22JIX0 $PINS Q=n_125 A=n_54 B=activation[3][7] C=FE_DBTN0_n_54
+ D=activation_reg[3][7]
Xg3508__6783 AO22JIX0 $PINS Q=n_124 A=n_54 B=activation[4][0] C=FE_DBTN0_n_54
+ D=activation_reg[4][0]
Xg3509__3680 AO22JIX0 $PINS Q=n_123 A=n_54 B=activation[4][1] C=FE_DBTN0_n_54
+ D=activation_reg[4][1]
Xg3510__1617 AO22JIX0 $PINS Q=n_122 A=n_54 B=activation[4][2] C=FE_DBTN0_n_54
+ D=activation_reg[4][2]
Xg3511__2802 AO22JIX0 $PINS Q=n_121 A=n_54 B=activation[4][3] C=FE_DBTN0_n_54
+ D=activation_reg[4][3]
Xg3512__1705 AO22JIX0 $PINS Q=n_120 A=n_54 B=activation[4][4] C=FE_DBTN0_n_54
+ D=activation_reg[4][4]
Xg3513__5122 AO22JIX0 $PINS Q=n_119 A=n_54 B=activation[4][5] C=FE_DBTN0_n_54
+ D=activation_reg[4][5]
Xg3514__8246 AO22JIX0 $PINS Q=n_118 A=n_54 B=activation[4][6] C=FE_DBTN0_n_54
+ D=activation_reg[4][6]
Xg3515__7098 AO22JIX0 $PINS Q=n_117 A=n_54 B=activation[4][7] C=FE_DBTN0_n_54
+ D=activation_reg[4][7]
Xg3516__6131 AO22JIX0 $PINS Q=n_116 A=n_54 B=activation[5][0] C=FE_DBTN0_n_54
+ D=activation_reg[5][0]
Xg3517__1881 AO22JIX0 $PINS Q=n_115 A=n_54 B=activation[5][1] C=FE_DBTN0_n_54
+ D=activation_reg[5][1]
Xg3518__5115 AO22JIX0 $PINS Q=n_114 A=n_54 B=activation[5][2] C=FE_DBTN0_n_54
+ D=activation_reg[5][2]
Xg3519__7482 AO22JIX0 $PINS Q=n_113 A=n_54 B=activation[5][3] C=FE_DBTN0_n_54
+ D=activation_reg[5][3]
Xg3520__4733 AO22JIX0 $PINS Q=n_112 A=n_54 B=activation[5][4] C=FE_DBTN0_n_54
+ D=activation_reg[5][4]
Xg3521__6161 AO22JIX0 $PINS Q=n_111 A=n_54 B=activation[5][5] C=FE_DBTN0_n_54
+ D=activation_reg[5][5]
Xg3522__9315 AO22JIX0 $PINS Q=n_110 A=n_54 B=activation[5][6] C=FE_DBTN0_n_54
+ D=activation_reg[5][6]
Xg3523__9945 AO22JIX0 $PINS Q=n_109 A=n_54 B=activation[0][1] C=FE_DBTN0_n_54
+ D=activation_reg[0][1]
Xg3524__2883 AO22JIX0 $PINS Q=n_108 A=n_54 B=activation[5][7] C=FE_DBTN0_n_54
+ D=activation_reg[5][7]
Xg3525__2346 AO22JIX0 $PINS Q=n_107 A=n_54 B=activation[0][2] C=FE_DBTN0_n_54
+ D=activation_reg[0][2]
Xg3526__1666 AO22JIX0 $PINS Q=n_106 A=n_54 B=activation[0][3] C=FE_DBTN0_n_54
+ D=activation_reg[0][3]
Xg3527__7410 AO22JIX0 $PINS Q=n_105 A=n_54 B=activation[0][4] C=FE_DBTN0_n_54
+ D=activation_reg[0][4]
Xg3528__6417 AO22JIX0 $PINS Q=n_104 A=n_54 B=activation[0][0] C=FE_DBTN0_n_54
+ D=activation_reg[0][0]
Xg3529__5477 AO22JIX0 $PINS Q=n_103 A=n_54 B=activation[0][5] C=FE_DBTN0_n_54
+ D=activation_reg[0][5]
Xg3530__2398 AO22JIX0 $PINS Q=n_102 A=n_54 B=activation[0][7] C=FE_DBTN0_n_54
+ D=activation_reg[0][7]
Xg3531__5107 AO22JIX0 $PINS Q=n_101 A=n_54 B=activation[1][0] C=FE_DBTN0_n_54
+ D=activation_reg[1][0]
Xg3532__6260 AO22JIX0 $PINS Q=n_100 A=n_54 B=activation[0][6] C=FE_DBTN0_n_54
+ D=activation_reg[0][6]
Xg3533__4319 AO22JIX0 $PINS Q=n_99 A=n_54 B=activation[1][1] C=FE_DBTN0_n_54
+ D=activation_reg[1][1]
Xg3534__8428 AO22JIX0 $PINS Q=n_98 A=n_54 B=activation[1][2] C=FE_DBTN0_n_54
+ D=activation_reg[1][2]
Xg3535__5526 AO22JIX0 $PINS Q=n_97 A=n_54 B=activation[1][3] C=FE_DBTN0_n_54
+ D=activation_reg[1][3]
Xg3536__6783 AO22JIX0 $PINS Q=n_96 A=n_54 B=activation[1][4] C=FE_DBTN0_n_54
+ D=activation_reg[1][4]
Xg3537__3680 AO22JIX0 $PINS Q=n_95 A=n_54 B=activation[1][5] C=FE_DBTN0_n_54
+ D=activation_reg[1][5]
Xg3538__1617 AO22JIX0 $PINS Q=n_94 A=n_54 B=activation[1][6] C=FE_DBTN0_n_54
+ D=activation_reg[1][6]
Xg3539__2802 AO22JIX0 $PINS Q=n_93 A=n_54 B=activation[1][7] C=FE_DBTN0_n_54
+ D=activation_reg[1][7]
Xg3540__1705 AO22JIX0 $PINS Q=n_92 A=n_54 B=activation[2][0] C=FE_DBTN0_n_54
+ D=activation_reg[2][0]
Xg3541__5122 AO22JIX0 $PINS Q=n_91 A=n_54 B=activation[2][1] C=FE_DBTN0_n_54
+ D=activation_reg[2][1]
Xg3542__8246 AO22JIX0 $PINS Q=n_90 A=n_54 B=activation[2][2] C=FE_DBTN0_n_54
+ D=activation_reg[2][2]
Xg3543__7098 AO22JIX0 $PINS Q=n_89 A=n_54 B=activation[2][3] C=FE_DBTN0_n_54
+ D=activation_reg[2][3]
Xg3544__6131 AO22JIX0 $PINS Q=n_88 A=n_54 B=activation[2][4] C=FE_DBTN0_n_54
+ D=activation_reg[2][4]
Xg3545__1881 AO22JIX0 $PINS Q=n_87 A=n_54 B=activation[2][5] C=FE_DBTN0_n_54
+ D=activation_reg[2][5]
Xg3546__5115 AO22JIX0 $PINS Q=n_85 A=n_47 B=result[4][1] C=en D=am_result[4][1]
Xg3547__7482 AO22JIX0 $PINS Q=n_84 A=n_47 B=result[5][3] C=en D=am_result[5][3]
Xg3548__4733 AO22JIX0 $PINS Q=n_83 A=n_47 B=result[5][0] C=en D=am_result[5][0]
Xg3549__6161 AO22JIX0 $PINS Q=n_82 A=n_47 B=result[5][1] C=en D=am_result[5][1]
Xg3550__9315 AO22JIX0 $PINS Q=n_81 A=n_47 B=result[4][4] C=en D=am_result[4][4]
Xg3551__9945 AO22JIX0 $PINS Q=n_80 A=n_47 B=result[4][0] C=en D=am_result[4][0]
Xg3552__2883 AO22JIX0 $PINS Q=n_79 A=n_47 B=result[0][2] C=en D=am_result[0][2]
Xg3553__2346 AO22JIX0 $PINS Q=n_78 A=n_47 B=result[1][0] C=en D=am_result[1][0]
Xg3554__1666 AO22JIX0 $PINS Q=n_77 A=n_47 B=result[4][2] C=en D=am_result[4][2]
Xg3555__7410 AO22JIX0 $PINS Q=n_76 A=n_47 B=result[5][4] C=en D=am_result[5][4]
Xg3556__6417 AO22JIX0 $PINS Q=n_75 A=n_47 B=result[0][0] C=en D=am_result[0][0]
Xg3557__5477 AO22JIX0 $PINS Q=n_74 A=n_47 B=result[0][1] C=en D=am_result[0][1]
Xg3558__2398 AO22JIX0 $PINS Q=n_73 A=n_47 B=result[0][3] C=en D=am_result[0][3]
Xg3559__5107 AO22JIX0 $PINS Q=n_72 A=n_47 B=result[0][4] C=en D=am_result[0][4]
Xg3560__6260 ON21JIX0 $PINS Q=n_86 A=en B=start C=n_55
Xg3561__4319 AO22JIX0 $PINS Q=n_71 A=n_47 B=result[5][2] C=en D=am_result[5][2]
Xg3562__8428 AO22JIX0 $PINS Q=n_70 A=n_47 B=result[1][2] C=en D=am_result[1][2]
Xg3563__5526 AO22JIX0 $PINS Q=n_69 A=n_47 B=result[1][4] C=en D=am_result[1][4]
Xg3564__6783 AO22JIX0 $PINS Q=n_68 A=n_47 B=result[2][4] C=en D=am_result[2][4]
Xg3565__3680 AO22JIX0 $PINS Q=n_67 A=n_47 B=result[2][1] C=en D=am_result[2][1]
Xg3566__1617 AO22JIX0 $PINS Q=n_66 A=n_47 B=result[2][2] C=en D=am_result[2][2]
Xg3567__2802 AO22JIX0 $PINS Q=n_65 A=n_47 B=result[2][3] C=en D=am_result[2][3]
Xg3568__1705 AO22JIX0 $PINS Q=n_64 A=n_47 B=result[1][3] C=en D=am_result[1][3]
Xg3569__5122 AO22JIX0 $PINS Q=n_63 A=n_47 B=result[3][0] C=en D=am_result[3][0]
Xg3570__8246 AO22JIX0 $PINS Q=n_62 A=n_47 B=result[3][3] C=en D=am_result[3][3]
Xg3571__7098 AO22JIX0 $PINS Q=n_61 A=n_47 B=result[3][1] C=en D=am_result[3][1]
Xg3572__6131 AO22JIX0 $PINS Q=n_60 A=n_47 B=result[3][4] C=en D=am_result[3][4]
Xg3573__1881 AO22JIX0 $PINS Q=n_59 A=n_47 B=result[3][2] C=en D=am_result[3][2]
Xg3574__5115 AO22JIX0 $PINS Q=n_58 A=n_47 B=result[4][3] C=en D=am_result[4][3]
Xg3575__7482 AO22JIX0 $PINS Q=n_57 A=n_47 B=result[2][0] C=en D=am_result[2][0]
Xg3576__4733 AO22JIX0 $PINS Q=n_56 A=n_47 B=result[1][1] C=en D=am_result[1][1]
Xg3577__6161 NA2JIX0 $PINS Q=n_55 A=n_48 B=en
Xg3582__9315 AND2JIX1 $PINS Q=n_54 A=n_47 B=start
Xg3584 INVJIX0 $PINS Q=n_49 A=cycle_counter[1]
Xg3585 INVJIX0 $PINS Q=n_48 A=cycle_counter[0]
Xg3586 INVJIX0 $PINS Q=n_47 A=en
.ENDS

.SUBCKT adder_nbit_N5 A[4] A[3] A[2] A[1] A[0] B[4] B[3] B[2] B[1] B[0] Sum[5]
+ Sum[4] Sum[3] Sum[2] Sum[1] Sum[0]
Xg294__9945 NA2JIX1 $PINS Q=Sum[5] A=n_30 B=n_8
Xg295__2883 EO2JIX1 $PINS Q=Sum[4] A=n_29 B=n_15
Xg296__2346 NA2JIX0 $PINS Q=n_30 A=n_29 B=n_10
Xg297__1666 NA2JIX1 $PINS Q=n_29 A=n_27 B=n_7
Xg298__7410 EO2JIX1 $PINS Q=Sum[3] A=n_26 B=n_18
Xg299__6417 NA2JIX1 $PINS Q=n_27 A=n_26 B=n_11
Xg300__5477 NA2JIX1 $PINS Q=n_26 A=n_24 B=n_5
Xg301__2398 EO2JIX1 $PINS Q=Sum[2] A=n_23 B=n_17
Xg302__5107 NA2JIX1 $PINS Q=n_24 A=n_23 B=n_14
Xg303__6260 NA2JIX1 $PINS Q=n_23 A=n_21 B=n_6
Xg304__4319 EO2JIX1 $PINS Q=Sum[1] A=n_16 B=n_20
Xg305__8428 NA2JIX1 $PINS Q=n_21 A=n_20 B=n_13
Xg306 INVJIX1 $PINS Q=n_20 A=n_9
Xg307__5526 NO2I1JIX1 $PINS Q=Sum[0] AN=n_9 B=n_12
Xg308__6783 EO2JIX0 $PINS Q=n_18 A=B[3] B=A[3]
Xg309__3680 EO2JIX1 $PINS Q=n_17 A=B[2] B=A[2]
Xg310__1617 EO2JIX1 $PINS Q=n_16 A=B[1] B=A[1]
Xg311__2802 EO2JIX0 $PINS Q=n_15 A=B[4] B=A[4]
Xg312__1705 OR2JIX0 $PINS Q=n_14 A=A[2] B=B[2]
Xg313__5122 NA2JIX1 $PINS Q=n_13 A=n_3 B=n_2
Xg314__8246 NO2JIX0 $PINS Q=n_12 A=B[0] B=A[0]
Xg315__7098 OR2JIX0 $PINS Q=n_11 A=A[3] B=B[3]
Xg316__6131 OR2JIX0 $PINS Q=n_10 A=A[4] B=B[4]
Xg317__1881 NA2JIX0 $PINS Q=n_8 A=B[4] B=A[4]
Xg318__5115 NA2JIX0 $PINS Q=n_7 A=B[3] B=A[3]
Xg319__7482 NA2JIX1 $PINS Q=n_6 A=B[1] B=A[1]
Xg320__4733 NA2JIX0 $PINS Q=n_5 A=B[2] B=A[2]
Xg321__6161 NA2JIX1 $PINS Q=n_9 A=B[0] B=A[0]
Xg323 INVJIX1 $PINS Q=n_3 A=B[1]
Xg325 INVJIX1 $PINS Q=n_2 A=A[1]
.ENDS

.SUBCKT adder_nbit_N5_158 A[4] A[3] A[2] A[1] A[0] B[4] B[3] B[2] B[1] B[0]
+ Sum[5] Sum[4] Sum[3] Sum[2] Sum[1] Sum[0]
Xg294__9315 NA2JIX1 $PINS Q=Sum[5] A=n_30 B=n_8
Xg295__9945 EO2JIX1 $PINS Q=Sum[4] A=n_29 B=n_15
Xg296__2883 NA2JIX0 $PINS Q=n_30 A=n_29 B=n_10
Xg297__2346 NA2JIX1 $PINS Q=n_29 A=n_27 B=n_7
Xg298__1666 EO2JIX1 $PINS Q=Sum[3] A=n_26 B=n_18
Xg299__7410 NA2JIX1 $PINS Q=n_27 A=n_26 B=n_11
Xg300__6417 NA2JIX1 $PINS Q=n_26 A=n_24 B=n_5
Xg301__5477 EO2JIX1 $PINS Q=Sum[2] A=n_23 B=n_17
Xg302__2398 NA2JIX1 $PINS Q=n_24 A=n_23 B=n_14
Xg303__5107 NA2JIX1 $PINS Q=n_23 A=n_21 B=n_6
Xg304__6260 EO2JIX1 $PINS Q=Sum[1] A=n_16 B=n_20
Xg305__4319 NA2JIX1 $PINS Q=n_21 A=n_20 B=n_13
Xg306 INVJIX1 $PINS Q=n_20 A=n_9
Xg307__8428 NO2I1JIX1 $PINS Q=Sum[0] AN=n_9 B=n_12
Xg308__5526 EO2JIX0 $PINS Q=n_18 A=B[3] B=A[3]
Xg309__6783 EO2JIX1 $PINS Q=n_17 A=B[2] B=A[2]
Xg310__3680 EO2JIX1 $PINS Q=n_16 A=B[1] B=A[1]
Xg311__1617 EO2JIX0 $PINS Q=n_15 A=B[4] B=A[4]
Xg312__2802 OR2JIX0 $PINS Q=n_14 A=A[2] B=B[2]
Xg313__1705 NA2JIX1 $PINS Q=n_13 A=n_3 B=n_2
Xg314__5122 NO2JIX0 $PINS Q=n_12 A=B[0] B=A[0]
Xg315__8246 OR2JIX0 $PINS Q=n_11 A=A[3] B=B[3]
Xg316__7098 OR2JIX0 $PINS Q=n_10 A=A[4] B=B[4]
Xg317__6131 NA2JIX0 $PINS Q=n_8 A=B[4] B=A[4]
Xg318__1881 NA2JIX0 $PINS Q=n_7 A=B[3] B=A[3]
Xg319__5115 NA2JIX1 $PINS Q=n_6 A=B[1] B=A[1]
Xg320__7482 NA2JIX0 $PINS Q=n_5 A=B[2] B=A[2]
Xg321__4733 NA2JIX1 $PINS Q=n_9 A=B[0] B=A[0]
Xg323 INVJIX1 $PINS Q=n_3 A=B[1]
Xg325 INVJIX1 $PINS Q=n_2 A=A[1]
.ENDS

.SUBCKT adder_nbit_N5_157 A[4] A[3] A[2] A[1] A[0] B[4] B[3] B[2] B[1] B[0]
+ Sum[5] Sum[4] Sum[3] Sum[2] Sum[1] Sum[0]
Xg294__6161 AO22JIX0 $PINS Q=Sum[5] A=n_23 B=n_8 C=B[4] D=A[4]
Xg295__9315 EO2JIX1 $PINS Q=Sum[4] A=n_23 B=n_13
Xg296__9945 NA2JIX1 $PINS Q=n_23 A=n_21 B=n_9
Xg297__2883 EO2JIX1 $PINS Q=Sum[3] A=n_20 B=n_15
Xg298__2346 NA2JIX1 $PINS Q=n_21 A=n_20 B=n_11
Xg299__1666 NA2JIX1 $PINS Q=n_20 A=n_18 B=n_7
Xg300__7410 EO2JIX1 $PINS Q=Sum[2] A=n_17 B=n_14
Xg301__6417 NA2JIX0 $PINS Q=n_18 A=n_17 B=n_12
Xg302__5477 NA2JIX1 $PINS Q=n_17 A=n_3 B=n_10
Xg303__2398 EO3JIX0 $PINS Q=Sum[1] A=n_4 B=B[1] C=A[1]
Xg307__5107 EO2JIX0 $PINS Q=n_15 A=B[3] B=A[3]
Xg308__6260 EO2JIX1 $PINS Q=n_14 A=n_6 B=n_5
Xg309__4319 EO2JIX0 $PINS Q=n_13 A=B[4] B=A[4]
Xg311__8428 NA2JIX0 $PINS Q=n_12 A=n_5 B=n_6
Xg312__5526 OR2JIX0 $PINS Q=n_11 A=A[3] B=B[3]
Xg313__6783 NA2JIX0 $PINS Q=n_10 A=B[1] B=A[1]
Xg314__3680 NA2JIX0 $PINS Q=n_9 A=B[3] B=A[3]
Xg315__1617 OR2JIX0 $PINS Q=n_8 A=A[4] B=B[4]
Xg316__2802 NA2JIX0 $PINS Q=n_7 A=B[2] B=A[2]
Xg318 INVJIX1 $PINS Q=n_6 A=A[2]
Xg320 INVJIX1 $PINS Q=n_5 A=B[2]
Xg2__1705 AND2JIX0 $PINS Q=n_4 A=B[0] B=A[0]
Xg323__5122 ON211JIX1 $PINS Q=n_3 A=B[1] B=A[1] C=B[0] D=A[0]
Xg333__8246 EO2JIX1 $PINS Q=Sum[0] A=B[0] B=A[0]
.ENDS

.SUBCKT adder_nbit_N6 A[5] A[4] A[3] A[2] A[1] A[0] B[5] B[4] B[3] B[2] B[1]
+ B[0] Sum[6] Sum[5] Sum[4] Sum[3] Sum[2] Sum[1] Sum[0]
Xg380__7098 NA2I1JIX1 $PINS Q=Sum[6] AN=n_10 B=n_37
Xg381__6131 EO2JIX1 $PINS Q=Sum[5] A=n_36 B=n_22
Xg382__1881 NA2JIX0 $PINS Q=n_37 A=n_36 B=n_14
Xg383__5115 NA2JIX1 $PINS Q=n_36 A=n_34 B=n_11
Xg384__7482 EO2JIX1 $PINS Q=Sum[4] A=n_21 B=n_33
Xg385__4733 NA2JIX1 $PINS Q=n_34 A=n_33 B=n_16
Xg386__6161 NA2JIX1 $PINS Q=n_33 A=n_31 B=n_13
Xg387__9315 EO2JIX1 $PINS Q=Sum[3] A=n_30 B=n_20
Xg388__9945 NA2JIX1 $PINS Q=n_31 A=n_30 B=n_17
Xg389__2883 NA2JIX1 $PINS Q=n_30 A=n_28 B=n_12
Xg390__2346 EO2JIX1 $PINS Q=Sum[2] A=n_27 B=n_19
Xg391__1666 NA2JIX1 $PINS Q=n_28 A=n_27 B=n_15
Xg392__7410 NA2JIX1 $PINS Q=n_27 A=n_25 B=n_0
Xg393__6417 EO2JIX1 $PINS Q=Sum[1] A=n_18 B=n_24
Xg394__5477 NA2JIX1 $PINS Q=n_25 A=n_1 B=n_24
Xg395__2398 HAJIX1 $PINS CO=n_24 S=Sum[0] A=A[0] B=B[0]
Xg396__5107 EO2JIX0 $PINS Q=n_22 A=B[5] B=A[5]
Xg397__6260 EO2JIX1 $PINS Q=n_21 A=B[4] B=A[4]
Xg398__4319 EO2JIX1 $PINS Q=n_20 A=B[3] B=A[3]
Xg399__8428 EO2JIX1 $PINS Q=n_19 A=B[2] B=A[2]
Xg400__5526 EO2JIX1 $PINS Q=n_18 A=B[1] B=A[1]
Xg401__6783 NA2I1JIX1 $PINS Q=n_17 AN=B[3] B=n_4
Xg403__3680 NA2JIX0 $PINS Q=n_16 A=n_3 B=n_5
Xg404__1617 NA2I1JIX1 $PINS Q=n_15 AN=B[2] B=n_2
Xg405__2802 OR2JIX0 $PINS Q=n_14 A=A[5] B=B[5]
Xg406__1705 NA2JIX0 $PINS Q=n_13 A=B[3] B=A[3]
Xg407__5122 NA2JIX0 $PINS Q=n_12 A=B[2] B=A[2]
Xg408__8246 NA2JIX0 $PINS Q=n_11 A=B[4] B=A[4]
Xg410__7098 AND2JIX0 $PINS Q=n_10 A=B[5] B=A[5]
Xg414 INVJIX1 $PINS Q=n_8 A=A[1]
Xg417 INVJIX1 $PINS Q=n_6 A=B[1]
Xg418 INVJIX0 $PINS Q=n_5 A=A[4]
Xg419 INVJIX0 $PINS Q=n_4 A=A[3]
Xg420 INVJIX0 $PINS Q=n_3 A=B[4]
Xg421 INVJIX0 $PINS Q=n_2 A=A[2]
Xg2__6131 NA2I1JIX1 $PINS Q=n_1 AN=A[1] B=n_6
Xg422__1881 NA2I1JIX1 $PINS Q=n_0 AN=n_8 B=B[1]
.ENDS

.SUBCKT adder_nbit_N6_1 A[5] A[4] A[3] A[2] A[1] A[0] B[5] B[4] B[3] B[2] B[1]
+ B[0] Sum[6] Sum[5] Sum[4] Sum[3] Sum[2] Sum[1] Sum[0]
*.CONNECT Sum[0] VSS
Xg72__5115 EO2JIX1 $PINS Q=Sum[1] A=A[1] B=B[1]
Xg83__7482 EO2JIX1 $PINS Q=Sum[2] A=n_14 B=n_16
Xg84__4733 EN2JIX0 $PINS Q=n_14 A=A[2] B=B[2]
Xg86__6161 NA2JIX1 $PINS Q=n_16 A=A[1] B=B[1]
Xg156__9315 NA2JIX1 $PINS Q=Sum[5] A=Sum[6] B=n_12
Xg159__9945 NA2JIX0 $PINS Q=n_12 A=n_11 B=A[5]
Xg160__2883 NA2JIX0 $PINS Q=n_11 A=n_10 B=n_4
Xg161__2346 EO2JIX1 $PINS Q=Sum[4] A=n_8 B=n_6
Xg162__1666 ON21JIX1 $PINS Q=n_10 A=A[4] B=B[4] C=n_8
Xg164__7410 NA2JIX1 $PINS Q=n_8 A=n_7 B=n_5
Xg165__6417 ON21JIX1 $PINS Q=n_7 A=A[3] B=B[3] C=Carry[3]
Xg166__5477 EO2JIX1 $PINS Q=n_6 A=A[4] B=B[4]
Xg167__2398 NA2JIX0 $PINS Q=n_5 A=A[3] B=B[3]
Xg168__5107 NA2JIX0 $PINS Q=n_4 A=A[4] B=B[4]
Xg2__6260 NA3I1JIX0 $PINS Q=Sum[6] AN=A[5] B=n_10 C=n_4
Xg109__4319 EO2JIX1 $PINS Q=Sum[3] A=n_2 B=Carry[3]
Xg111__8428 ON21JIX1 $PINS Q=Carry[3] A=n_1 B=n_16 C=n_0
Xg112__5526 EO2JIX1 $PINS Q=n_2 A=A[3] B=B[3]
Xg113__6783 NO2JIX1 $PINS Q=n_1 A=A[2] B=B[2]
Xg114__3680 NA2JIX1 $PINS Q=n_0 A=A[2] B=B[2]
.ENDS

.SUBCKT adder_nbit_N7 A[6] A[5] A[4] A[3] A[2] A[1] A[0] B[6] B[5] B[4] B[3]
+ B[2] B[1] B[0] Sum[7] Sum[6] Sum[5] Sum[4] Sum[3] Sum[2] Sum[1] Sum[0]
Xg138__1617 EO2JIX0 $PINS Q=Sum[0] A=A[0] B=B[0]
Xg149__2802 EN3JIX0 $PINS Q=Sum[1] A=A[1] B=B[1] C=n_24
Xg150__1705 NA2JIX0 $PINS Q=n_24 A=A[0] B=B[0]
Xg175__5122 EO3JIX0 $PINS Q=Sum[2] A=Carry[2] B=A[2] C=B[2]
Xg177__8246 ON21JIX1 $PINS Q=Carry[2] A=n_22 B=n_24 C=n_21
Xg178__7098 NO2JIX1 $PINS Q=n_22 A=B[1] B=A[1]
Xg179__6131 NA2JIX0 $PINS Q=n_21 A=A[1] B=B[1]
Xg180__1881 EO3JIX0 $PINS Q=Sum[3] A=Carry[3] B=A[3] C=B[3]
Xg181__5115 NA2JIX1 $PINS Q=Carry[3] A=n_20 B=n_19
Xg182__7482 NA2JIX1 $PINS Q=n_20 A=n_18 B=Carry[2]
Xg183__4733 NA2JIX0 $PINS Q=n_19 A=A[2] B=B[2]
Xg2__6161 OR2JIX0 $PINS Q=n_18 A=A[2] B=B[2]
Xg291__9315 NA2JIX1 $PINS Q=Sum[7] A=n_17 B=n_5
Xg292__9945 EO2JIX1 $PINS Q=Sum[6] A=n_16 B=n_10
Xg293__2883 NA2JIX0 $PINS Q=n_17 A=n_4 B=n_16
Xg294__2346 NA2JIX1 $PINS Q=n_16 A=n_15 B=n_3
Xg295__1666 EO2JIX0 $PINS Q=Sum[5] A=n_12 B=n_14
Xg296__7410 ON21JIX1 $PINS Q=n_15 A=B[5] B=A[5] C=n_14
Xg297__6417 ON21JIX1 $PINS Q=n_14 A=n_9 B=n_13 C=n_6
Xg298__5477 EN2JIX0 $PINS Q=Sum[4] A=n_11 B=n_13
Xg299__2398 AN21JIX1 $PINS Q=n_13 A=Carry[3] B=n_7 C=n_8
Xg300__5107 EO2JIX0 $PINS Q=n_12 A=A[5] B=B[5]
Xg301__6260 EO2JIX0 $PINS Q=n_11 A=A[4] B=B[4]
Xg302__4319 EO2JIX1 $PINS Q=n_10 A=A[6] B=B[6]
Xg303__8428 NO2JIX1 $PINS Q=n_9 A=A[4] B=B[4]
Xg304__5526 AND2JIX0 $PINS Q=n_8 A=A[3] B=B[3]
Xg305__6783 NA2JIX1 $PINS Q=n_7 A=n_1 B=n_2
Xg306__3680 NA2JIX0 $PINS Q=n_6 A=A[4] B=B[4]
Xg307__1617 NA2JIX0 $PINS Q=n_5 A=A[6] B=B[6]
Xg308__2802 OR2JIX0 $PINS Q=n_4 A=A[6] B=B[6]
Xg309__1705 NA2JIX0 $PINS Q=n_3 A=A[5] B=B[5]
Xg310 INVJIX0 $PINS Q=n_2 A=B[3]
Xg311 INVJIX0 $PINS Q=n_1 A=A[3]
.ENDS

.SUBCKT AdderTree_6_WEIGHT_WIDTH8_NUM_UNITS6 input_data[0][7] input_data[0][6]
+ input_data[0][5] input_data[0][4] input_data[0][3] input_data[0][2]
+ input_data[0][1] input_data[0][0] input_data[1][7] input_data[1][6]
+ input_data[1][5] input_data[1][4] input_data[1][3] input_data[1][2]
+ input_data[1][1] input_data[1][0] input_data[2][7] input_data[2][6]
+ input_data[2][5] input_data[2][4] input_data[2][3] input_data[2][2]
+ input_data[2][1] input_data[2][0] input_data[3][7] input_data[3][6]
+ input_data[3][5] input_data[3][4] input_data[3][3] input_data[3][2]
+ input_data[3][1] input_data[3][0] input_data[4][7] input_data[4][6]
+ input_data[4][5] input_data[4][4] input_data[4][3] input_data[4][2]
+ input_data[4][1] input_data[4][0] input_data[5][7] input_data[5][6]
+ input_data[5][5] input_data[5][4] input_data[5][3] input_data[5][2]
+ input_data[5][1] input_data[5][0] clk rst sum_combinational[10]
+ sum_combinational[9] sum_combinational[8] sum_combinational[7]
+ sum_combinational[6] sum_combinational[5] sum_combinational[4]
+ sum_combinational[3] sum_combinational[2] sum_combinational[1]
+ sum_combinational[0] DFT_/sen DFT_/sdo SPCASCAN_N0 sum_out_2 SPCASCAN_N4
+ sum_out_1 SPCBSCAN_N6
*.CONNECT sum_out_2 sum_out[2]
*.CONNECT sum_out_1 sum_out[1]
*.CONNECT sum_combinational[0] VSS
*.CONNECT sum_combinational[1] VSS
*.CONNECT sum_combinational[2] VSS
*.CONNECT sum_combinational[3] VSS
*.CONNECT sum_combinational[8] VSS
*.CONNECT sum_combinational[9] VSS
*.CONNECT sum_combinational[10] VSS
XL1_ADD[0].inst_L1 adder_nbit_N5 $PINS A[4]=input_data[0][4]
+ A[3]=input_data[0][3] A[2]=input_data[0][2] A[1]=input_data[0][1]
+ A[0]=input_data[0][0] B[4]=input_data[1][4] B[3]=input_data[1][3]
+ B[2]=input_data[1][2] B[1]=input_data[1][1] B[0]=input_data[1][0]
+ Sum[5]=int_sum_L1[0][5] Sum[4]=int_sum_L1[0][4] Sum[3]=int_sum_L1[0][3]
+ Sum[2]=int_sum_L1[0][2] Sum[1]=int_sum_L1[0][1] Sum[0]=int_sum_L1[0][0]
XL1_ADD[1].inst_L1 adder_nbit_N5_158 $PINS A[4]=input_data[2][4]
+ A[3]=input_data[2][3] A[2]=input_data[2][2] A[1]=input_data[2][1]
+ A[0]=input_data[2][0] B[4]=input_data[3][4] B[3]=input_data[3][3]
+ B[2]=input_data[3][2] B[1]=input_data[3][1] B[0]=input_data[3][0]
+ Sum[5]=int_sum_L1[1][5] Sum[4]=int_sum_L1[1][4] Sum[3]=int_sum_L1[1][3]
+ Sum[2]=int_sum_L1[1][2] Sum[1]=int_sum_L1[1][1] Sum[0]=int_sum_L1[1][0]
XL1_ADD[2].inst_L1 adder_nbit_N5_157 $PINS A[4]=input_data[4][4]
+ A[3]=input_data[4][3] A[2]=input_data[4][2] A[1]=input_data[4][1]
+ A[0]=input_data[4][0] B[4]=input_data[5][4] B[3]=input_data[5][3]
+ B[2]=input_data[5][2] B[1]=input_data[5][1] B[0]=input_data[5][0]
+ Sum[5]=int_sum_L1[2][5] Sum[4]=int_sum_L1[2][4] Sum[3]=int_sum_L1[2][3]
+ Sum[2]=int_sum_L1[2][2] Sum[1]=int_sum_L1[2][1] Sum[0]=int_sum_L1[2][0]
Xinst_L2 adder_nbit_N6 $PINS A[5]=int_sum_L1[0][5] A[4]=int_sum_L1[0][4]
+ A[3]=int_sum_L1[0][3] A[2]=int_sum_L1[0][2] A[1]=int_sum_L1[0][1]
+ A[0]=int_sum_L1[0][0] B[5]=int_sum_L1[1][5] B[4]=int_sum_L1[1][4]
+ B[3]=int_sum_L1[1][3] B[2]=int_sum_L1[1][2] B[1]=int_sum_L1[1][1]
+ B[0]=int_sum_L1[1][0] Sum[6]=int_sum_L2[0][6] Sum[5]=int_sum_L2[0][5]
+ Sum[4]=int_sum_L2[0][4] Sum[3]=int_sum_L2[0][3] Sum[2]=int_sum_L2[0][2]
+ Sum[1]=int_sum_L2[0][1] Sum[0]=int_sum_L2[0][0]
Xinst_L2_extra adder_nbit_N6_1 $PINS A[5]=int_sum_L1[2][5]
+ A[4]=int_sum_L1[2][4] A[3]=int_sum_L1[2][3] A[2]=int_sum_L1[2][2]
+ A[1]=int_sum_L1[2][1] A[0]=VSS B[5]=VDD B[4]=DFT_/sdo B[3]=sum_out[2]
+ B[2]=sum_out[1] B[1]=sum_out[0] B[0]=VSS Sum[6]=int_sum_L2[1][6]
+ Sum[5]=int_sum_L2[1][5] Sum[4]=int_sum_L2[1][4] Sum[3]=int_sum_L2[1][3]
+ Sum[2]=int_sum_L2[1][2] Sum[1]=int_sum_L2[1][1] Sum[0]=UNCONNECTED
Xinst_L6_0 adder_nbit_N7 $PINS A[6]=int_sum_L2[0][6] A[5]=int_sum_L2[0][5]
+ A[4]=int_sum_L2[0][4] A[3]=int_sum_L2[0][3] A[2]=int_sum_L2[0][2]
+ A[1]=int_sum_L2[0][1] A[0]=int_sum_L2[0][0] B[6]=int_sum_L2[1][6]
+ B[5]=int_sum_L2[1][5] B[4]=int_sum_L2[1][4] B[3]=int_sum_L2[1][3]
+ B[2]=int_sum_L2[1][2] B[1]=int_sum_L2[1][1] B[0]=int_sum_L1[2][0]
+ Sum[7]=sum_combinational[7] Sum[6]=sum_combinational[6]
+ Sum[5]=sum_combinational[5] Sum[4]=sum_combinational[4] Sum[3]=n_40 Sum[2]=n_41
+ Sum[1]=n_42 Sum[0]=n_43
Xsum_out_reg[3] SDFRQJIX1 $PINS Q=DFT_/sdo C=clk D=n_3 SD=sum_out_2 SE=DFT_/sen
Xg9__5122 NO2I1JIX0 $PINS Q=n_3 AN=n_40 B=rst
Xsum_out_reg[2] SDFRQJIX1 $PINS Q=sum_out[2] C=clk D=n_2 SD=SPCBSCAN_N6
+ SE=DFT_/sen
Xg11__8246 NO2I1JIX0 $PINS Q=n_2 AN=n_41 B=rst
Xsum_out_reg[1] SDFRQJIX1 $PINS Q=sum_out[1] C=clk D=n_1 SD=sum_out[0]
+ SE=DFT_/sen
Xg13__7098 NO2I1JIX0 $PINS Q=n_1 AN=n_42 B=rst
Xsum_out_reg[0] SDFRQJIX1 $PINS Q=sum_out[0] C=clk D=n_0 SD=SPCASCAN_N4
+ SE=DFT_/sen
Xg15__6131 NO2I1JIX0 $PINS Q=n_0 AN=n_43 B=rst
.ENDS

.SUBCKT Out_Gen_Func clk reset IN[3] IN[2] IN[1] IN[0] z_p z_n DFT_/sdi
+ DFT_/sen R1 p_1 R2 p_2 R0
XR3_reg SDFRRQJIX1 $PINS Q=z_n C=clk D=n_13 RN=n_1 SD=R2 SE=DFT_/sen
Xg253__1881 NA2JIX1 $PINS Q=z_p A=n_12 B=n_0
Xg254__5115 EO2JIX0 $PINS Q=n_13 A=n_9 B=n_11
Xg255__7482 NA2JIX0 $PINS Q=n_12 A=n_9 B=n_10
Xg256__4733 EO2JIX0 $PINS Q=n_11 A=IN[3] B=R2
Xg257__6161 NA2I1JIX0 $PINS Q=n_10 AN=R2 B=n_2
XR2_reg SDFRRQJIX1 $PINS Q=R2 C=clk D=n_8 RN=n_1 SD=p_1 SE=DFT_/sen
Xg260__9315 ON21JIX1 $PINS Q=n_9 A=n_7 B=n_3 C=n_6
Xg261__9945 EN3JIX0 $PINS Q=n_8 A=n_3 B=IN[2] C=R1
Xg262__2883 NO2JIX1 $PINS Q=n_7 A=IN[2] B=R1
Xg263__2346 NA2JIX0 $PINS Q=n_6 A=IN[2] B=R1
XR1_reg SDFRRQJIX1 $PINS Q=R1 C=clk D=n_5 RN=n_1 SD=DFT_/sdi SE=DFT_/sen
Xg265__1666 NO2I1JIX0 $PINS Q=n_5 AN=n_3 B=n_4
Xg266__7410 NO2JIX0 $PINS Q=n_4 A=IN[1] B=R0
Xg267__6417 NA2JIX1 $PINS Q=n_3 A=IN[1] B=R0
XR0_reg SDFRRQJIX1 $PINS Q=R0 C=clk D=IN[0] RN=n_1 SD=R1 SE=DFT_/sen
Xg270 INVJIX0 $PINS Q=n_2 A=IN[3]
Xg271 INVJIX0 $PINS Q=n_1 A=reset
Xg2__5477 NA2I1JIX0 $PINS Q=n_0 AN=n_2 B=R2
.ENDS

.SUBCKT Main weight[0][7] weight[0][6] weight[0][5] weight[0][4] weight[0][3]
+ weight[0][2] weight[0][1] weight[0][0] weight[1][7] weight[1][6] weight[1][5]
+ weight[1][4] weight[1][3] weight[1][2] weight[1][1] weight[1][0] weight[2][7]
+ weight[2][6] weight[2][5] weight[2][4] weight[2][3] weight[2][2] weight[2][1]
+ weight[2][0] weight[3][7] weight[3][6] weight[3][5] weight[3][4] weight[3][3]
+ weight[3][2] weight[3][1] weight[3][0] weight[4][7] weight[4][6] weight[4][5]
+ weight[4][4] weight[4][3] weight[4][2] weight[4][1] weight[4][0] weight[5][7]
+ weight[5][6] weight[5][5] weight[5][4] weight[5][3] weight[5][2] weight[5][1]
+ weight[5][0] activation[0][7] activation[0][6] activation[0][5]
+ activation[0][4] activation[0][3] activation[0][2] activation[0][1]
+ activation[0][0] activation[1][7] activation[1][6] activation[1][5]
+ activation[1][4] activation[1][3] activation[1][2] activation[1][1]
+ activation[1][0] activation[2][7] activation[2][6] activation[2][5]
+ activation[2][4] activation[2][3] activation[2][2] activation[2][1]
+ activation[2][0] activation[3][7] activation[3][6] activation[3][5]
+ activation[3][4] activation[3][3] activation[3][2] activation[3][1]
+ activation[3][0] activation[4][7] activation[4][6] activation[4][5]
+ activation[4][4] activation[4][3] activation[4][2] activation[4][1]
+ activation[4][0] activation[5][7] activation[5][6] activation[5][5]
+ activation[5][4] activation[5][3] activation[5][2] activation[5][1]
+ activation[5][0] start clk rst en z_p z_n scan_en scan_in scan_out
*.CONNECT scan_out z_n
XA6M ActivationMultiplier_6_IN_WIDTH8_NUM_UNITS6_ACTIVATION_WIDTH8 $PINS
+ activation[0][7]=activation[0][7] activation[0][6]=activation[0][6]
+ activation[0][5]=activation[0][5] activation[0][4]=activation[0][4]
+ activation[0][3]=activation[0][3] activation[0][2]=activation[0][2]
+ activation[0][1]=activation[0][1] activation[0][0]=activation[0][0]
+ activation[1][7]=activation[1][7] activation[1][6]=activation[1][6]
+ activation[1][5]=activation[1][5] activation[1][4]=activation[1][4]
+ activation[1][3]=activation[1][3] activation[1][2]=activation[1][2]
+ activation[1][1]=activation[1][1] activation[1][0]=activation[1][0]
+ activation[2][7]=activation[2][7] activation[2][6]=activation[2][6]
+ activation[2][5]=activation[2][5] activation[2][4]=activation[2][4]
+ activation[2][3]=activation[2][3] activation[2][2]=activation[2][2]
+ activation[2][1]=activation[2][1] activation[2][0]=activation[2][0]
+ activation[3][7]=activation[3][7] activation[3][6]=activation[3][6]
+ activation[3][5]=activation[3][5] activation[3][4]=activation[3][4]
+ activation[3][3]=activation[3][3] activation[3][2]=activation[3][2]
+ activation[3][1]=activation[3][1] activation[3][0]=activation[3][0]
+ activation[4][7]=activation[4][7] activation[4][6]=activation[4][6]
+ activation[4][5]=activation[4][5] activation[4][4]=activation[4][4]
+ activation[4][3]=activation[4][3] activation[4][2]=activation[4][2]
+ activation[4][1]=activation[4][1] activation[4][0]=activation[4][0]
+ activation[5][7]=activation[5][7] activation[5][6]=activation[5][6]
+ activation[5][5]=activation[5][5] activation[5][4]=activation[5][4]
+ activation[5][3]=activation[5][3] activation[5][2]=activation[5][2]
+ activation[5][1]=activation[5][1] activation[5][0]=activation[5][0]
+ weight[0][7]=weight[0][7] weight[0][6]=weight[0][6] weight[0][5]=weight[0][5]
+ weight[0][4]=weight[0][4] weight[0][3]=weight[0][3] weight[0][2]=weight[0][2]
+ weight[0][1]=weight[0][1] weight[0][0]=weight[0][0] weight[1][7]=weight[1][7]
+ weight[1][6]=weight[1][6] weight[1][5]=weight[1][5] weight[1][4]=weight[1][4]
+ weight[1][3]=weight[1][3] weight[1][2]=weight[1][2] weight[1][1]=weight[1][1]
+ weight[1][0]=weight[1][0] weight[2][7]=weight[2][7] weight[2][6]=weight[2][6]
+ weight[2][5]=weight[2][5] weight[2][4]=weight[2][4] weight[2][3]=weight[2][3]
+ weight[2][2]=weight[2][2] weight[2][1]=weight[2][1] weight[2][0]=weight[2][0]
+ weight[3][7]=weight[3][7] weight[3][6]=weight[3][6] weight[3][5]=weight[3][5]
+ weight[3][4]=weight[3][4] weight[3][3]=weight[3][3] weight[3][2]=weight[3][2]
+ weight[3][1]=weight[3][1] weight[3][0]=weight[3][0] weight[4][7]=weight[4][7]
+ weight[4][6]=weight[4][6] weight[4][5]=weight[4][5] weight[4][4]=weight[4][4]
+ weight[4][3]=weight[4][3] weight[4][2]=weight[4][2] weight[4][1]=weight[4][1]
+ weight[4][0]=weight[4][0] weight[5][7]=weight[5][7] weight[5][6]=weight[5][6]
+ weight[5][5]=weight[5][5] weight[5][4]=weight[5][4] weight[5][3]=weight[5][3]
+ weight[5][2]=weight[5][2] weight[5][1]=weight[5][1] weight[5][0]=weight[5][0]
+ clk=clk rst=rst start=start result[0][7]=result[0][7] result[0][6]=result[0][6]
+ result[0][5]=result[0][5] result[0][4]=result[0][4] result[0][3]=result[0][3]
+ result[0][2]=result[0][2] result[0][1]=result[0][1] result[0][0]=result[0][0]
+ result[1][7]=result[1][7] result[1][6]=result[1][6] result[1][5]=result[1][5]
+ result[1][4]=result[1][4] result[1][3]=result[1][3] result[1][2]=result[1][2]
+ result[1][1]=result[1][1] result[1][0]=result[1][0] result[2][7]=result[2][7]
+ result[2][6]=result[2][6] result[2][5]=result[2][5] result[2][4]=result[2][4]
+ result[2][3]=result[2][3] result[2][2]=result[2][2] result[2][1]=result[2][1]
+ result[2][0]=result[2][0] result[3][7]=result[3][7] result[3][6]=result[3][6]
+ result[3][5]=result[3][5] result[3][4]=result[3][4] result[3][3]=result[3][3]
+ result[3][2]=result[3][2] result[3][1]=result[3][1] result[3][0]=result[3][0]
+ result[4][7]=result[4][7] result[4][6]=result[4][6] result[4][5]=result[4][5]
+ result[4][4]=result[4][4] result[4][3]=result[4][3] result[4][2]=result[4][2]
+ result[4][1]=result[4][1] result[4][0]=result[4][0] result[5][7]=result[5][7]
+ result[5][6]=result[5][6] result[5][5]=result[5][5] result[5][4]=result[5][4]
+ result[5][3]=result[5][3] result[5][2]=result[5][2] result[5][1]=result[5][1]
+ result[5][0]=result[5][0] en=en DFT_/sdi=scan_in DFT_/sen=scan_en
+ n_0=SPCASCAN_N0 SPCASCAN_N1=SPCASCAN_N1 p_1=n_105 SPCASCAN_N2=SPCASCAN_N2
+ SPCASCAN_N3=SPCASCAN_N3 n_3=SPCASCAN_N4 SPCASCAN_N5=SPCASCAN_N5
XAT6 AdderTree_6_WEIGHT_WIDTH8_NUM_UNITS6 $PINS input_data[0][7]=VSS
+ input_data[0][6]=VSS input_data[0][5]=VSS input_data[0][4]=result[0][4]
+ input_data[0][3]=result[0][3] input_data[0][2]=result[0][2]
+ input_data[0][1]=result[0][1] input_data[0][0]=result[0][0]
+ input_data[1][7]=VSS input_data[1][6]=VSS input_data[1][5]=VSS
+ input_data[1][4]=result[1][4] input_data[1][3]=result[1][3]
+ input_data[1][2]=result[1][2] input_data[1][1]=result[1][1]
+ input_data[1][0]=result[1][0] input_data[2][7]=VSS input_data[2][6]=VSS
+ input_data[2][5]=VSS input_data[2][4]=result[2][4]
+ input_data[2][3]=result[2][3] input_data[2][2]=result[2][2]
+ input_data[2][1]=result[2][1] input_data[2][0]=result[2][0]
+ input_data[3][7]=VSS input_data[3][6]=VSS input_data[3][5]=VSS
+ input_data[3][4]=result[3][4] input_data[3][3]=result[3][3]
+ input_data[3][2]=result[3][2] input_data[3][1]=result[3][1]
+ input_data[3][0]=result[3][0] input_data[4][7]=VSS input_data[4][6]=VSS
+ input_data[4][5]=VSS input_data[4][4]=result[4][4]
+ input_data[4][3]=result[4][3] input_data[4][2]=result[4][2]
+ input_data[4][1]=result[4][1] input_data[4][0]=result[4][0]
+ input_data[5][7]=VSS input_data[5][6]=VSS input_data[5][5]=VSS
+ input_data[5][4]=result[5][4] input_data[5][3]=result[5][3]
+ input_data[5][2]=result[5][2] input_data[5][1]=result[5][1]
+ input_data[5][0]=result[5][0] clk=clk rst=rst
+ sum_combinational[10]=sum_combinational[10]
+ sum_combinational[9]=sum_combinational[9]
+ sum_combinational[8]=sum_combinational[8]
+ sum_combinational[7]=sum_combinational[7]
+ sum_combinational[6]=sum_combinational[6]
+ sum_combinational[5]=sum_combinational[5]
+ sum_combinational[4]=sum_combinational[4]
+ sum_combinational[3]=sum_combinational[3]
+ sum_combinational[2]=sum_combinational[2]
+ sum_combinational[1]=sum_combinational[1]
+ sum_combinational[0]=sum_combinational[0] DFT_/sen=scan_en DFT_/sdo=n_105
+ SPCASCAN_N0=SPCASCAN_N0 sum_out_2=SPCASCAN_N1 SPCASCAN_N4=SPCASCAN_N4
+ sum_out_1=SPCASCAN_N5 SPCBSCAN_N6=SPCBSCAN_N6
XOGF Out_Gen_Func $PINS clk=clk reset=rst IN[3]=sum_combinational[7]
+ IN[2]=sum_combinational[6] IN[1]=sum_combinational[5]
+ IN[0]=sum_combinational[4] z_p=z_p z_n=z_n DFT_/sdi=result[5][4]
+ DFT_/sen=scan_en R1=SPCASCAN_N2 p_1=result[3][4] R2=SPCASCAN_N3
+ p_2=result[0][4] R0=SPCBSCAN_N6
.ENDS
.GLOBAL VDD
.GLOBAL VSS
