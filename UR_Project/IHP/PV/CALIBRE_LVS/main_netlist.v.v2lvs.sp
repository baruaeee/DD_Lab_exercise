$ Spice netlist generated by v2lvs
$ v2024.4_12.9    Tue Oct 1 20:33:59 PDT 2024
*.BUSDELIMITER [

.SUBCKT ActivationMultiplier_6_IN_WIDTH8_NUM_UNITS6_ACTIVATION_WIDTH8
+ activation[0][7] activation[0][6] activation[0][5] activation[0][4]
+ activation[0][3] activation[0][2] activation[0][1] activation[0][0]
+ activation[1][7] activation[1][6] activation[1][5] activation[1][4]
+ activation[1][3] activation[1][2] activation[1][1] activation[1][0]
+ activation[2][7] activation[2][6] activation[2][5] activation[2][4]
+ activation[2][3] activation[2][2] activation[2][1] activation[2][0]
+ activation[3][7] activation[3][6] activation[3][5] activation[3][4]
+ activation[3][3] activation[3][2] activation[3][1] activation[3][0]
+ activation[4][7] activation[4][6] activation[4][5] activation[4][4]
+ activation[4][3] activation[4][2] activation[4][1] activation[4][0]
+ activation[5][7] activation[5][6] activation[5][5] activation[5][4]
+ activation[5][3] activation[5][2] activation[5][1] activation[5][0]
+ weight[0][7] weight[0][6] weight[0][5] weight[0][4] weight[0][3] weight[0][2]
+ weight[0][1] weight[0][0] weight[1][7] weight[1][6] weight[1][5] weight[1][4]
+ weight[1][3] weight[1][2] weight[1][1] weight[1][0] weight[2][7] weight[2][6]
+ weight[2][5] weight[2][4] weight[2][3] weight[2][2] weight[2][1] weight[2][0]
+ weight[3][7] weight[3][6] weight[3][5] weight[3][4] weight[3][3] weight[3][2]
+ weight[3][1] weight[3][0] weight[4][7] weight[4][6] weight[4][5] weight[4][4]
+ weight[4][3] weight[4][2] weight[4][1] weight[4][0] weight[5][7] weight[5][6]
+ weight[5][5] weight[5][4] weight[5][3] weight[5][2] weight[5][1] weight[5][0]
+ clk rst start result[0][7] result[0][6] result[0][5] result[0][4]
+ result[0][3] result[0][2] result[0][1] result[0][0] result[1][7] result[1][6]
+ result[1][5] result[1][4] result[1][3] result[1][2] result[1][1] result[1][0]
+ result[2][7] result[2][6] result[2][5] result[2][4] result[2][3] result[2][2]
+ result[2][1] result[2][0] result[3][7] result[3][6] result[3][5] result[3][4]
+ result[3][3] result[3][2] result[3][1] result[3][0] result[4][7] result[4][6]
+ result[4][5] result[4][4] result[4][3] result[4][2] result[4][1] result[4][0]
+ result[5][7] result[5][6] result[5][5] result[5][4] result[5][3] result[5][2]
+ result[5][1] result[5][0] en DFT_/sdi DFT_/sen
*.CONNECT result[5][5] VSS
*.CONNECT result[5][6] VSS
*.CONNECT result[5][7] VSS
*.CONNECT result[4][5] VSS
*.CONNECT result[4][6] VSS
*.CONNECT result[4][7] VSS
*.CONNECT result[3][5] VSS
*.CONNECT result[3][6] VSS
*.CONNECT result[3][7] VSS
*.CONNECT result[2][5] VSS
*.CONNECT result[2][6] VSS
*.CONNECT result[2][7] VSS
*.CONNECT result[1][5] VSS
*.CONNECT result[1][6] VSS
*.CONNECT result[1][7] VSS
*.CONNECT result[0][5] VSS
*.CONNECT result[0][6] VSS
*.CONNECT result[0][7] VSS
XAM_INST[0].am ActivationMultiplier_IN_WIDTH8 $PINS weight[7]=weight[0][7]
+ weight[6]=weight[0][6] weight[5]=weight[0][5] weight[4]=weight[0][4]
+ weight[3]=weight[0][3] weight[2]=weight[0][2] weight[1]=weight[0][1]
+ weight[0]=weight[0][0] activation=n_184 en=en_542 result[7]=am_result[0][7]
+ result[6]=am_result[0][6] result[5]=am_result[0][5] result[4]=am_result[0][4]
+ result[3]=am_result[0][3] result[2]=am_result[0][2] result[1]=am_result[0][1]
+ result[0]=am_result[0][0]
XAM_INST[1].am ActivationMultiplier_IN_WIDTH8 $PINS weight[7]=weight[1][7]
+ weight[6]=weight[1][6] weight[5]=weight[1][5] weight[4]=weight[1][4]
+ weight[3]=weight[1][3] weight[2]=weight[1][2] weight[1]=weight[1][1]
+ weight[0]=weight[1][0] activation=n_188 en=en_542 result[7]=am_result[1][7]
+ result[6]=am_result[1][6] result[5]=am_result[1][5] result[4]=am_result[1][4]
+ result[3]=am_result[1][3] result[2]=am_result[1][2] result[1]=am_result[1][1]
+ result[0]=am_result[1][0]
XAM_INST[2].am ActivationMultiplier_IN_WIDTH8 $PINS weight[7]=weight[2][7]
+ weight[6]=weight[2][6] weight[5]=weight[2][5] weight[4]=weight[2][4]
+ weight[3]=weight[2][3] weight[2]=weight[2][2] weight[1]=weight[2][1]
+ weight[0]=weight[2][0] activation=n_187 en=en_542 result[7]=am_result[2][7]
+ result[6]=am_result[2][6] result[5]=am_result[2][5] result[4]=am_result[2][4]
+ result[3]=am_result[2][3] result[2]=am_result[2][2] result[1]=am_result[2][1]
+ result[0]=am_result[2][0]
XAM_INST[3].am ActivationMultiplier_IN_WIDTH8 $PINS weight[7]=weight[3][7]
+ weight[6]=weight[3][6] weight[5]=weight[3][5] weight[4]=weight[3][4]
+ weight[3]=weight[3][3] weight[2]=weight[3][2] weight[1]=weight[3][1]
+ weight[0]=weight[3][0] activation=n_186 en=en_542 result[7]=am_result[3][7]
+ result[6]=am_result[3][6] result[5]=am_result[3][5] result[4]=am_result[3][4]
+ result[3]=am_result[3][3] result[2]=am_result[3][2] result[1]=am_result[3][1]
+ result[0]=am_result[3][0]
XAM_INST[4].am ActivationMultiplier_IN_WIDTH8 $PINS weight[7]=weight[4][7]
+ weight[6]=weight[4][6] weight[5]=weight[4][5] weight[4]=weight[4][4]
+ weight[3]=weight[4][3] weight[2]=weight[4][2] weight[1]=weight[4][1]
+ weight[0]=weight[4][0] activation=n_185 en=en_542 result[7]=am_result[4][7]
+ result[6]=am_result[4][6] result[5]=am_result[4][5] result[4]=am_result[4][4]
+ result[3]=am_result[4][3] result[2]=am_result[4][2] result[1]=am_result[4][1]
+ result[0]=am_result[4][0]
XAM_INST[5].am ActivationMultiplier_IN_WIDTH8 $PINS weight[7]=weight[5][7]
+ weight[6]=weight[5][6] weight[5]=weight[5][5] weight[4]=weight[5][4]
+ weight[3]=weight[5][3] weight[2]=weight[5][2] weight[1]=weight[5][1]
+ weight[0]=weight[5][0] activation=n_189 en=en_542 result[7]=am_result[5][7]
+ result[6]=am_result[5][6] result[5]=am_result[5][5] result[4]=am_result[5][4]
+ result[3]=am_result[5][3] result[2]=am_result[5][2] result[1]=am_result[5][1]
+ result[0]=am_result[5][0]
Xg2407 BUFJIX1 $PINS A=en_542 Q=en
Xg2406 INJIX0 $PINS A=rst Q=n_180
Xg3309__2398 NA4JIX0 $PINS A=n_169 B=n_171 C=n_165 D=n_160 Q=n_184
Xg3310__5107 NA4JIX0 $PINS A=n_167 B=n_163 C=n_179 D=n_157 Q=n_185
Xg3311__6260 NA4JIX0 $PINS A=n_172 B=n_175 C=n_177 D=n_159 Q=n_186
Xg3312__4319 NA4JIX0 $PINS A=n_173 B=n_176 C=n_174 D=n_161 Q=n_189
Xg3313__8428 NA4JIX0 $PINS A=n_168 B=n_162 C=n_166 D=n_158 Q=n_187
Xg3314__5526 NA4JIX0 $PINS A=n_164 B=n_178 C=n_170 D=n_156 Q=n_188
Xg3315__6783 AN22JIX0 $PINS A=n_151 B=activation_reg[4][1] C=n_147
+ D=activation_reg[4][0] Q=n_179
Xg3316__3680 AN22JIX0 $PINS A=n_152 B=activation_reg[1][7] C=n_155
+ D=activation_reg[1][3] Q=n_178
Xg3317__1617 AN22JIX0 $PINS A=n_151 B=activation_reg[3][1] C=n_147
+ D=activation_reg[3][0] Q=n_177
Xg3318__2802 AN22JIX0 $PINS A=n_152 B=activation_reg[5][7] C=n_155
+ D=activation_reg[5][3] Q=n_176
Xg3319__1705 AN22JIX0 $PINS A=n_152 B=activation_reg[3][7] C=n_155
+ D=activation_reg[3][3] Q=n_175
Xg3320__5122 AN22JIX0 $PINS A=n_151 B=activation_reg[5][1] C=n_147
+ D=activation_reg[5][0] Q=n_174
Xg3321__8246 AN22JIX0 $PINS A=n_153 B=activation_reg[5][6] C=n_154
+ D=activation_reg[5][2] Q=n_173
Xg3322__7098 AN22JIX0 $PINS A=n_153 B=activation_reg[3][6] C=n_154
+ D=activation_reg[3][2] Q=n_172
Xg3323__6131 AN22JIX0 $PINS A=n_152 B=activation_reg[0][7] C=n_155
+ D=activation_reg[0][3] Q=n_171
Xg3324__1881 AN22JIX0 $PINS A=n_151 B=activation_reg[1][1] C=n_147
+ D=activation_reg[1][0] Q=n_170
Xg3325__5115 AN22JIX0 $PINS A=n_153 B=activation_reg[0][6] C=n_154
+ D=activation_reg[0][2] Q=n_169
Xg3326__7482 AN22JIX0 $PINS A=n_153 B=activation_reg[2][6] C=n_154
+ D=activation_reg[2][2] Q=n_168
Xg3327__4733 AN22JIX0 $PINS A=n_153 B=activation_reg[4][6] C=n_154
+ D=activation_reg[4][2] Q=n_167
Xg3328__6161 AN22JIX0 $PINS A=n_151 B=activation_reg[2][1] C=n_147
+ D=activation_reg[2][0] Q=n_166
Xg3329__9315 AN22JIX0 $PINS A=n_151 B=activation_reg[0][1] C=n_147
+ D=activation_reg[0][0] Q=n_165
Xg3330__9945 AN22JIX0 $PINS A=n_153 B=activation_reg[1][6] C=n_154
+ D=activation_reg[1][2] Q=n_164
Xg3331__2883 AN22JIX0 $PINS A=n_152 B=activation_reg[4][7] C=n_155
+ D=activation_reg[4][3] Q=n_163
Xg3332__2346 AN22JIX0 $PINS A=n_152 B=activation_reg[2][7] C=n_155
+ D=activation_reg[2][3] Q=n_162
Xg3333__1666 AN22JIX0 $PINS A=n_149 B=activation_reg[5][5] C=n_146
+ D=activation_reg[5][4] Q=n_161
Xg3334__7410 AN22JIX0 $PINS A=n_149 B=activation_reg[0][5] C=n_146
+ D=activation_reg[0][4] Q=n_160
Xg3335__6417 AN22JIX0 $PINS A=n_149 B=activation_reg[3][5] C=n_146
+ D=activation_reg[3][4] Q=n_159
Xg3336__5477 AN22JIX0 $PINS A=n_149 B=activation_reg[2][5] C=n_146
+ D=activation_reg[2][4] Q=n_158
Xg3337__2398 AN22JIX0 $PINS A=n_149 B=activation_reg[4][5] C=n_146
+ D=activation_reg[4][4] Q=n_157
Xg3338__5107 AN22JIX0 $PINS A=n_149 B=activation_reg[1][5] C=n_146
+ D=activation_reg[1][4] Q=n_156
Xg3339__6260 AND2JIX0 $PINS A=n_150 B=cycle_counter[2] Q=n_155
Xg3340__4319 AND2JIX0 $PINS A=n_148 B=cycle_counter[2] Q=n_154
Xg3341__8428 NO2I1JIX0 $PINS AN=n_148 B=cycle_counter[2] Q=n_153
Xg3342__5526 NO2I1JIX0 $PINS AN=n_150 B=cycle_counter[2] Q=n_152
Xg3343__6783 AND3JIX0 $PINS A=n_144 B=cycle_counter[2] C=cycle_counter[1]
+ Q=n_151
Xg3344__3680 NO2I1JIX0 $PINS AN=n_144 B=cycle_counter[1] Q=n_150
Xg3345__1617 NO2I1JIX0 $PINS AN=n_144 B=n_190 Q=n_149
Xg3346 INVJIX0 $PINS A=n_192 Q=n_147
Xg3347 INVJIX0 $PINS A=n_146 Q=n_191
Xg3348__2802 NO2JIX0 $PINS A=n_145 B=cycle_counter[1] Q=n_148
Xg3350__1705 NO2JIX0 $PINS A=n_145 B=n_190 Q=n_146
Xg3352__5122 NA2I1JIX0 $PINS AN=cycle_counter[3] B=cycle_counter[0] Q=n_145
Xg3353__8246 NO2JIX0 $PINS A=cycle_counter[3] B=cycle_counter[0] Q=n_144
Xg3354__7098 NA2I1JIX0 $PINS AN=cycle_counter[2] B=cycle_counter[1] Q=n_190
Xg2__6131 NA3I1JIX0 $PINS AN=n_145 B=cycle_counter[1] C=cycle_counter[2]
+ Q=n_192
Xactivation_reg_reg[0][0] SDFRRQJIX1 $PINS RN=n_180 C=clk D=n_104 SD=DFT_/sdi
+ SE=DFT_/sen Q=activation_reg[0][0]
Xactivation_reg_reg[0][1] SDFRRQJIX1 $PINS RN=n_180 C=clk D=n_109
+ SD=activation_reg[0][0] SE=DFT_/sen Q=activation_reg[0][1]
Xactivation_reg_reg[0][2] SDFRRQJIX1 $PINS RN=n_180 C=clk D=n_107
+ SD=activation_reg[0][1] SE=DFT_/sen Q=activation_reg[0][2]
Xactivation_reg_reg[0][3] SDFRRQJIX1 $PINS RN=n_180 C=clk D=n_106
+ SD=activation_reg[0][2] SE=DFT_/sen Q=activation_reg[0][3]
Xactivation_reg_reg[0][4] SDFRRQJIX1 $PINS RN=n_180 C=clk D=n_105
+ SD=activation_reg[0][3] SE=DFT_/sen Q=activation_reg[0][4]
Xactivation_reg_reg[0][5] SDFRRQJIX1 $PINS RN=n_180 C=clk D=n_103
+ SD=activation_reg[0][4] SE=DFT_/sen Q=activation_reg[0][5]
Xactivation_reg_reg[0][6] SDFRRQJIX1 $PINS RN=n_180 C=clk D=n_100
+ SD=activation_reg[0][5] SE=DFT_/sen Q=activation_reg[0][6]
Xactivation_reg_reg[0][7] SDFRRQJIX1 $PINS RN=n_180 C=clk D=n_102
+ SD=activation_reg[0][6] SE=DFT_/sen Q=activation_reg[0][7]
Xactivation_reg_reg[1][0] SDFRRQJIX1 $PINS RN=n_180 C=clk D=n_101
+ SD=activation_reg[0][7] SE=DFT_/sen Q=activation_reg[1][0]
Xactivation_reg_reg[1][1] SDFRRQJIX1 $PINS RN=n_180 C=clk D=n_99
+ SD=activation_reg[1][0] SE=DFT_/sen Q=activation_reg[1][1]
Xactivation_reg_reg[1][2] SDFRRQJIX1 $PINS RN=n_180 C=clk D=n_98
+ SD=activation_reg[1][1] SE=DFT_/sen Q=activation_reg[1][2]
Xactivation_reg_reg[1][3] SDFRRQJIX1 $PINS RN=n_180 C=clk D=n_97
+ SD=activation_reg[1][2] SE=DFT_/sen Q=activation_reg[1][3]
Xactivation_reg_reg[1][4] SDFRRQJIX1 $PINS RN=n_180 C=clk D=n_96
+ SD=activation_reg[1][3] SE=DFT_/sen Q=activation_reg[1][4]
Xactivation_reg_reg[1][5] SDFRRQJIX1 $PINS RN=n_180 C=clk D=n_95
+ SD=activation_reg[1][4] SE=DFT_/sen Q=activation_reg[1][5]
Xactivation_reg_reg[1][6] SDFRRQJIX1 $PINS RN=n_180 C=clk D=n_94
+ SD=activation_reg[1][5] SE=DFT_/sen Q=activation_reg[1][6]
Xactivation_reg_reg[1][7] SDFRRQJIX1 $PINS RN=n_180 C=clk D=n_93
+ SD=activation_reg[1][6] SE=DFT_/sen Q=activation_reg[1][7]
Xactivation_reg_reg[2][0] SDFRRQJIX1 $PINS RN=n_180 C=clk D=n_92
+ SD=activation_reg[1][7] SE=DFT_/sen Q=activation_reg[2][0]
Xactivation_reg_reg[2][1] SDFRRQJIX1 $PINS RN=n_180 C=clk D=n_91
+ SD=activation_reg[2][0] SE=DFT_/sen Q=activation_reg[2][1]
Xactivation_reg_reg[2][2] SDFRRQJIX1 $PINS RN=n_180 C=clk D=n_90
+ SD=activation_reg[2][1] SE=DFT_/sen Q=activation_reg[2][2]
Xactivation_reg_reg[2][3] SDFRRQJIX1 $PINS RN=n_180 C=clk D=n_89
+ SD=activation_reg[2][2] SE=DFT_/sen Q=activation_reg[2][3]
Xactivation_reg_reg[2][4] SDFRRQJIX1 $PINS RN=n_180 C=clk D=n_88
+ SD=activation_reg[2][3] SE=DFT_/sen Q=activation_reg[2][4]
Xactivation_reg_reg[2][5] SDFRRQJIX1 $PINS RN=n_180 C=clk D=n_87
+ SD=activation_reg[2][4] SE=DFT_/sen Q=activation_reg[2][5]
Xactivation_reg_reg[2][6] SDFRRQJIX1 $PINS RN=n_180 C=clk D=n_132
+ SD=activation_reg[2][5] SE=DFT_/sen Q=activation_reg[2][6]
Xactivation_reg_reg[2][7] SDFRRQJIX1 $PINS RN=n_180 C=clk D=n_134
+ SD=activation_reg[2][6] SE=DFT_/sen Q=activation_reg[2][7]
Xactivation_reg_reg[3][0] SDFRRQJIX1 $PINS RN=n_180 C=clk D=n_133
+ SD=activation_reg[2][7] SE=DFT_/sen Q=activation_reg[3][0]
Xactivation_reg_reg[3][1] SDFRRQJIX1 $PINS RN=n_180 C=clk D=n_131
+ SD=activation_reg[3][0] SE=DFT_/sen Q=activation_reg[3][1]
Xactivation_reg_reg[3][2] SDFRRQJIX1 $PINS RN=n_180 C=clk D=n_130
+ SD=activation_reg[3][1] SE=DFT_/sen Q=activation_reg[3][2]
Xactivation_reg_reg[3][3] SDFRRQJIX1 $PINS RN=n_180 C=clk D=n_129
+ SD=activation_reg[3][2] SE=DFT_/sen Q=activation_reg[3][3]
Xactivation_reg_reg[3][4] SDFRRQJIX1 $PINS RN=n_180 C=clk D=n_136
+ SD=activation_reg[3][3] SE=DFT_/sen Q=activation_reg[3][4]
Xactivation_reg_reg[3][5] SDFRRQJIX1 $PINS RN=n_180 C=clk D=n_127
+ SD=activation_reg[3][4] SE=DFT_/sen Q=activation_reg[3][5]
Xactivation_reg_reg[3][6] SDFRRQJIX1 $PINS RN=n_180 C=clk D=n_126
+ SD=activation_reg[3][5] SE=DFT_/sen Q=activation_reg[3][6]
Xactivation_reg_reg[3][7] SDFRRQJIX1 $PINS RN=n_180 C=clk D=n_125
+ SD=activation_reg[3][6] SE=DFT_/sen Q=activation_reg[3][7]
Xactivation_reg_reg[4][0] SDFRRQJIX1 $PINS RN=n_180 C=clk D=n_124
+ SD=activation_reg[3][7] SE=DFT_/sen Q=activation_reg[4][0]
Xactivation_reg_reg[4][1] SDFRRQJIX1 $PINS RN=n_180 C=clk D=n_123
+ SD=activation_reg[4][0] SE=DFT_/sen Q=activation_reg[4][1]
Xactivation_reg_reg[4][2] SDFRRQJIX1 $PINS RN=n_180 C=clk D=n_122
+ SD=activation_reg[4][1] SE=DFT_/sen Q=activation_reg[4][2]
Xactivation_reg_reg[4][3] SDFRRQJIX1 $PINS RN=n_180 C=clk D=n_121
+ SD=activation_reg[4][2] SE=DFT_/sen Q=activation_reg[4][3]
Xactivation_reg_reg[4][4] SDFRRQJIX1 $PINS RN=n_180 C=clk D=n_120
+ SD=activation_reg[4][3] SE=DFT_/sen Q=activation_reg[4][4]
Xactivation_reg_reg[4][5] SDFRRQJIX1 $PINS RN=n_180 C=clk D=n_119
+ SD=activation_reg[4][4] SE=DFT_/sen Q=activation_reg[4][5]
Xactivation_reg_reg[4][6] SDFRRQJIX1 $PINS RN=n_180 C=clk D=n_118
+ SD=activation_reg[4][5] SE=DFT_/sen Q=activation_reg[4][6]
Xactivation_reg_reg[4][7] SDFRRQJIX1 $PINS RN=n_180 C=clk D=n_117
+ SD=activation_reg[4][6] SE=DFT_/sen Q=activation_reg[4][7]
Xactivation_reg_reg[5][0] SDFRRQJIX1 $PINS RN=n_180 C=clk D=n_116
+ SD=activation_reg[4][7] SE=DFT_/sen Q=activation_reg[5][0]
Xactivation_reg_reg[5][1] SDFRRQJIX1 $PINS RN=n_180 C=clk D=n_115
+ SD=activation_reg[5][0] SE=DFT_/sen Q=activation_reg[5][1]
Xactivation_reg_reg[5][2] SDFRRQJIX1 $PINS RN=n_180 C=clk D=n_114
+ SD=activation_reg[5][1] SE=DFT_/sen Q=activation_reg[5][2]
Xactivation_reg_reg[5][3] SDFRRQJIX1 $PINS RN=n_180 C=clk D=n_113
+ SD=activation_reg[5][2] SE=DFT_/sen Q=activation_reg[5][3]
Xactivation_reg_reg[5][4] SDFRRQJIX1 $PINS RN=n_180 C=clk D=n_112
+ SD=activation_reg[5][3] SE=DFT_/sen Q=activation_reg[5][4]
Xactivation_reg_reg[5][5] SDFRRQJIX1 $PINS RN=n_180 C=clk D=n_111
+ SD=activation_reg[5][4] SE=DFT_/sen Q=activation_reg[5][5]
Xactivation_reg_reg[5][6] SDFRRQJIX1 $PINS RN=n_180 C=clk D=n_110
+ SD=activation_reg[5][5] SE=DFT_/sen Q=activation_reg[5][6]
Xactivation_reg_reg[5][7] SDFRRQJIX1 $PINS RN=n_180 C=clk D=n_108
+ SD=activation_reg[5][6] SE=DFT_/sen Q=activation_reg[5][7]
Xcycle_counter_reg[0] SDFRRQJIX1 $PINS RN=n_180 C=clk D=n_128
+ SD=activation_reg[5][7] SE=DFT_/sen Q=cycle_counter[0]
Xcycle_counter_reg[1] SDFRRQJIX1 $PINS RN=n_180 C=clk D=n_140
+ SD=cycle_counter[0] SE=DFT_/sen Q=cycle_counter[1]
Xcycle_counter_reg[2] SDFRRQJIX1 $PINS RN=n_180 C=clk D=n_142
+ SD=cycle_counter[1] SE=DFT_/sen Q=cycle_counter[2]
Xcycle_counter_reg[3] SDFRRQJIX1 $PINS RN=n_180 C=clk D=n_141
+ SD=cycle_counter[2] SE=DFT_/sen Q=cycle_counter[3]
Xen_reg SDFRRQJIX1 $PINS RN=n_180 C=clk D=n_143 SD=cycle_counter[3] SE=DFT_/sen
+ Q=en_542
Xresult_reg[0][0] SDFRRSJIX1 $PINS RN=n_180 SN=VDD C=clk D=n_75 SD=en_542
+ SE=DFT_/sen Q=result[0][0] QN=n_17
Xresult_reg[0][1] SDFRRSJIX1 $PINS RN=n_180 SN=VDD C=clk D=n_74 SD=n_17
+ SE=DFT_/sen Q=result[0][1] QN=n_16
Xresult_reg[0][2] SDFRRSJIX1 $PINS RN=n_180 SN=VDD C=clk D=n_79 SD=n_16
+ SE=DFT_/sen Q=result[0][2] QN=n_15
Xresult_reg[0][3] SDFRRQJIX1 $PINS RN=n_180 C=clk D=n_73 SD=n_15 SE=DFT_/sen
+ Q=result[0][3]
Xresult_reg[0][4] SDFRRQJIX1 $PINS RN=n_180 C=clk D=n_72 SD=result[0][3]
+ SE=DFT_/sen Q=result[0][4]
Xresult_reg[1][0] SDFRRSJIX1 $PINS RN=n_180 SN=VDD C=clk D=n_78 SD=result[0][4]
+ SE=DFT_/sen Q=result[1][0] QN=n_14
Xresult_reg[1][1] SDFRRSJIX1 $PINS RN=n_180 SN=VDD C=clk D=n_56 SD=n_14
+ SE=DFT_/sen Q=result[1][1] QN=n_13
Xresult_reg[1][2] SDFRRSJIX1 $PINS RN=n_180 SN=VDD C=clk D=n_70 SD=n_13
+ SE=DFT_/sen Q=result[1][2] QN=n_12
Xresult_reg[1][3] SDFRRQJIX1 $PINS RN=n_180 C=clk D=n_64 SD=n_12 SE=DFT_/sen
+ Q=result[1][3]
Xresult_reg[1][4] SDFRRQJIX1 $PINS RN=n_180 C=clk D=n_69 SD=result[1][3]
+ SE=DFT_/sen Q=result[1][4]
Xresult_reg[2][0] SDFRRSJIX1 $PINS RN=n_180 SN=VDD C=clk D=n_57 SD=result[1][4]
+ SE=DFT_/sen Q=result[2][0] QN=n_11
Xresult_reg[2][1] SDFRRSJIX1 $PINS RN=n_180 SN=VDD C=clk D=n_67 SD=n_11
+ SE=DFT_/sen Q=result[2][1] QN=n_10
Xresult_reg[2][2] SDFRRSJIX1 $PINS RN=n_180 SN=VDD C=clk D=n_66 SD=n_10
+ SE=DFT_/sen Q=result[2][2] QN=n_9
Xresult_reg[2][3] SDFRRQJIX1 $PINS RN=n_180 C=clk D=n_65 SD=n_9 SE=DFT_/sen
+ Q=result[2][3]
Xresult_reg[2][4] SDFRRQJIX1 $PINS RN=n_180 C=clk D=n_68 SD=result[2][3]
+ SE=DFT_/sen Q=result[2][4]
Xresult_reg[3][0] SDFRRSJIX1 $PINS RN=n_180 SN=VDD C=clk D=n_63 SD=result[2][4]
+ SE=DFT_/sen Q=result[3][0] QN=n_8
Xresult_reg[3][1] SDFRRSJIX1 $PINS RN=n_180 SN=VDD C=clk D=n_61 SD=n_8
+ SE=DFT_/sen Q=result[3][1] QN=n_7
Xresult_reg[3][2] SDFRRSJIX1 $PINS RN=n_180 SN=VDD C=clk D=n_59 SD=n_7
+ SE=DFT_/sen Q=result[3][2] QN=n_6
Xresult_reg[3][3] SDFRRQJIX1 $PINS RN=n_180 C=clk D=n_62 SD=n_6 SE=DFT_/sen
+ Q=result[3][3]
Xresult_reg[3][4] SDFRRQJIX1 $PINS RN=n_180 C=clk D=n_60 SD=result[3][3]
+ SE=DFT_/sen Q=result[3][4]
Xresult_reg[4][0] SDFRRSJIX1 $PINS RN=n_180 SN=VDD C=clk D=n_80 SD=result[3][4]
+ SE=DFT_/sen Q=result[4][0] QN=n_5
Xresult_reg[4][1] SDFRRSJIX1 $PINS RN=n_180 SN=VDD C=clk D=n_85 SD=n_5
+ SE=DFT_/sen Q=result[4][1] QN=n_4
Xresult_reg[4][2] SDFRRSJIX1 $PINS RN=n_180 SN=VDD C=clk D=n_77 SD=n_4
+ SE=DFT_/sen Q=result[4][2] QN=n_3
Xresult_reg[4][3] SDFRRQJIX1 $PINS RN=n_180 C=clk D=n_58 SD=n_3 SE=DFT_/sen
+ Q=result[4][3]
Xresult_reg[4][4] SDFRRQJIX1 $PINS RN=n_180 C=clk D=n_81 SD=result[4][3]
+ SE=DFT_/sen Q=result[4][4]
Xresult_reg[5][0] SDFRRSJIX1 $PINS RN=n_180 SN=VDD C=clk D=n_83 SD=result[4][4]
+ SE=DFT_/sen Q=result[5][0] QN=n_2
Xresult_reg[5][1] SDFRRSJIX1 $PINS RN=n_180 SN=VDD C=clk D=n_82 SD=n_2
+ SE=DFT_/sen Q=result[5][1] QN=n_1
Xresult_reg[5][2] SDFRRSJIX1 $PINS RN=n_180 SN=VDD C=clk D=n_71 SD=n_1
+ SE=DFT_/sen Q=result[5][2] QN=n_0
Xresult_reg[5][3] SDFRRQJIX1 $PINS RN=n_180 C=clk D=n_84 SD=n_0 SE=DFT_/sen
+ Q=result[5][3]
Xresult_reg[5][4] SDFRRQJIX1 $PINS RN=n_180 C=clk D=n_76 SD=result[5][3]
+ SE=DFT_/sen Q=result[5][4]
Xg3409__1881 AO21JIX0 $PINS A=n_135 B=en_542 C=n_40 Q=n_143
Xg3411__5115 ON21JIX0 $PINS A=n_191 B=n_32 C=n_139 Q=n_142
Xg3412__7482 ON21JIX0 $PINS A=n_192 B=n_31 C=n_138 Q=n_141
Xg3439__4733 AO32JIX0 $PINS A=n_35 B=cycle_counter[0] C=n_49 D=cycle_counter[1]
+ E=n_86 Q=n_140
Xg3440__6161 NA2JIX0 $PINS A=n_137 B=cycle_counter[2] Q=n_139
Xg3441__9315 NA2JIX0 $PINS A=n_137 B=cycle_counter[3] Q=n_138
Xg3465__9945 AO22JIX0 $PINS A=n_40 B=activation[3][4] C=n_51
+ D=activation_reg[3][4] Q=n_136
Xg3466__2883 NA4I1JIX0 $PINS AN=n_190 B=cycle_counter[3] C=cycle_counter[0]
+ D=VDD Q=n_135
Xg3467__2346 AO22JIX0 $PINS A=n_54 B=activation[2][7] C=n_53
+ D=activation_reg[2][7] Q=n_134
Xg3468__1666 AO22JIX0 $PINS A=n_39 B=activation[3][0] C=n_23
+ D=activation_reg[3][0] Q=n_133
Xg3469__7410 AO22JIX0 $PINS A=n_41 B=activation[2][6] C=n_23
+ D=activation_reg[2][6] Q=n_132
Xg3470__6417 AO22JIX0 $PINS A=n_40 B=activation[3][1] C=n_51
+ D=activation_reg[3][1] Q=n_131
Xg3471__5477 AO22JIX0 $PINS A=n_40 B=activation[3][2] C=n_53
+ D=activation_reg[3][2] Q=n_130
Xg3472__2398 AO22JIX0 $PINS A=n_42 B=activation[3][3] C=n_26
+ D=activation_reg[3][3] Q=n_129
Xg3473__5107 ON31JIX0 $PINS A=start B=n_35 C=n_48 D=n_55 Q=n_128
Xg3495__6260 AO21JIX0 $PINS A=n_49 B=n_36 C=n_86 Q=n_137
Xg3505__4319 AO22JIX0 $PINS A=n_39 B=activation[3][5] C=n_51
+ D=activation_reg[3][5] Q=n_127
Xg3506__8428 AO22JIX0 $PINS A=n_54 B=activation[3][6] C=n_23
+ D=activation_reg[3][6] Q=n_126
Xg3507__5526 AO22JIX0 $PINS A=n_43 B=activation[3][7] C=n_52
+ D=activation_reg[3][7] Q=n_125
Xg3508__6783 AO22JIX0 $PINS A=n_42 B=activation[4][0] C=n_50
+ D=activation_reg[4][0] Q=n_124
Xg3509__3680 AO22JIX0 $PINS A=n_41 B=activation[4][1] C=n_23
+ D=activation_reg[4][1] Q=n_123
Xg3510__1617 AO22JIX0 $PINS A=n_45 B=activation[4][2] C=n_23
+ D=activation_reg[4][2] Q=n_122
Xg3511__2802 AO22JIX0 $PINS A=n_45 B=activation[4][3] C=n_23
+ D=activation_reg[4][3] Q=n_121
Xg3512__1705 AO22JIX0 $PINS A=n_42 B=activation[4][4] C=n_51
+ D=activation_reg[4][4] Q=n_120
Xg3513__5122 AO22JIX0 $PINS A=n_39 B=activation[4][5] C=n_53
+ D=activation_reg[4][5] Q=n_119
Xg3514__8246 AO22JIX0 $PINS A=n_41 B=activation[4][6] C=n_26
+ D=activation_reg[4][6] Q=n_118
Xg3515__7098 AO22JIX0 $PINS A=n_44 B=activation[4][7] C=n_23
+ D=activation_reg[4][7] Q=n_117
Xg3516__6131 AO22JIX0 $PINS A=n_44 B=activation[5][0] C=n_51
+ D=activation_reg[5][0] Q=n_116
Xg3517__1881 AO22JIX0 $PINS A=n_43 B=activation[5][1] C=n_25
+ D=activation_reg[5][1] Q=n_115
Xg3518__5115 AO22JIX0 $PINS A=n_42 B=activation[5][2] C=n_52
+ D=activation_reg[5][2] Q=n_114
Xg3519__7482 AO22JIX0 $PINS A=n_42 B=activation[5][3] C=n_25
+ D=activation_reg[5][3] Q=n_113
Xg3520__4733 AO22JIX0 $PINS A=n_39 B=activation[5][4] C=n_27
+ D=activation_reg[5][4] Q=n_112
Xg3521__6161 AO22JIX0 $PINS A=n_42 B=activation[5][5] C=n_27
+ D=activation_reg[5][5] Q=n_111
Xg3522__9315 AO22JIX0 $PINS A=n_43 B=activation[5][6] C=n_52
+ D=activation_reg[5][6] Q=n_110
Xg3523__9945 AO22JIX0 $PINS A=n_44 B=activation[0][1] C=n_51
+ D=activation_reg[0][1] Q=n_109
Xg3524__2883 AO22JIX0 $PINS A=n_43 B=activation[5][7] C=n_51
+ D=activation_reg[5][7] Q=n_108
Xg3525__2346 AO22JIX0 $PINS A=n_40 B=activation[0][2] C=n_25
+ D=activation_reg[0][2] Q=n_107
Xg3526__1666 AO22JIX0 $PINS A=n_54 B=activation[0][3] C=n_26
+ D=activation_reg[0][3] Q=n_106
Xg3527__7410 AO22JIX0 $PINS A=n_45 B=activation[0][4] C=n_50
+ D=activation_reg[0][4] Q=n_105
Xg3528__6417 AO22JIX0 $PINS A=n_41 B=activation[0][0] C=n_27
+ D=activation_reg[0][0] Q=n_104
Xg3529__5477 AO22JIX0 $PINS A=n_54 B=activation[0][5] C=n_27
+ D=activation_reg[0][5] Q=n_103
Xg3530__2398 AO22JIX0 $PINS A=n_44 B=activation[0][7] C=n_25
+ D=activation_reg[0][7] Q=n_102
Xg3531__5107 AO22JIX0 $PINS A=n_45 B=activation[1][0] C=n_26
+ D=activation_reg[1][0] Q=n_101
Xg3532__6260 AO22JIX0 $PINS A=n_41 B=activation[0][6] C=n_52
+ D=activation_reg[0][6] Q=n_100
Xg3533__4319 AO22JIX0 $PINS A=n_44 B=activation[1][1] C=n_53
+ D=activation_reg[1][1] Q=n_99
Xg3534__8428 AO22JIX0 $PINS A=n_43 B=activation[1][2] C=n_52
+ D=activation_reg[1][2] Q=n_98
Xg3535__5526 AO22JIX0 $PINS A=n_39 B=activation[1][3] C=n_27
+ D=activation_reg[1][3] Q=n_97
Xg3536__6783 AO22JIX0 $PINS A=n_40 B=activation[1][4] C=n_25
+ D=activation_reg[1][4] Q=n_96
Xg3537__3680 AO22JIX0 $PINS A=n_41 B=activation[1][5] C=n_53
+ D=activation_reg[1][5] Q=n_95
Xg3538__1617 AO22JIX0 $PINS A=n_42 B=activation[1][6] C=n_52
+ D=activation_reg[1][6] Q=n_94
Xg3539__2802 AO22JIX0 $PINS A=n_43 B=activation[1][7] C=n_26
+ D=activation_reg[1][7] Q=n_93
Xg3540__1705 AO22JIX0 $PINS A=n_39 B=activation[2][0] C=n_26
+ D=activation_reg[2][0] Q=n_92
Xg3541__5122 AO22JIX0 $PINS A=n_39 B=activation[2][1] C=n_52
+ D=activation_reg[2][1] Q=n_91
Xg3542__8246 AO22JIX0 $PINS A=n_41 B=activation[2][2] C=n_52
+ D=activation_reg[2][2] Q=n_90
Xg3543__7098 AO22JIX0 $PINS A=n_40 B=activation[2][3] C=n_25
+ D=activation_reg[2][3] Q=n_89
Xg3544__6131 AO22JIX0 $PINS A=n_54 B=activation[2][4] C=n_27
+ D=activation_reg[2][4] Q=n_88
Xg3545__1881 AO22JIX0 $PINS A=n_45 B=activation[2][5] C=n_53
+ D=activation_reg[2][5] Q=n_87
Xg3546__5115 AO22JIX0 $PINS A=n_29 B=result[4][1] C=n_19 D=am_result[4][1]
+ Q=n_85
Xg3547__7482 AO22JIX0 $PINS A=n_30 B=result[5][3] C=n_34 D=am_result[5][3]
+ Q=n_84
Xg3548__4733 AO22JIX0 $PINS A=n_21 B=result[5][0] C=n_34 D=am_result[5][0]
+ Q=n_83
Xg3549__6161 AO22JIX0 $PINS A=n_32 B=result[5][1] C=n_37 D=am_result[5][1]
+ Q=n_82
Xg3550__9315 AO22JIX0 $PINS A=n_29 B=result[4][4] C=n_22 D=am_result[4][4]
+ Q=n_81
Xg3551__9945 AO22JIX0 $PINS A=n_30 B=result[4][0] C=n_34 D=am_result[4][0]
+ Q=n_80
Xg3552__2883 AO22JIX0 $PINS A=n_31 B=result[0][2] C=n_36 D=am_result[0][2]
+ Q=n_79
Xg3553__2346 AO22JIX0 $PINS A=n_32 B=result[1][0] C=n_37 D=am_result[1][0]
+ Q=n_78
Xg3554__1666 AO22JIX0 $PINS A=n_29 B=result[4][2] C=n_35 D=am_result[4][2]
+ Q=n_77
Xg3555__7410 AO22JIX0 $PINS A=n_30 B=result[5][4] C=n_34 D=am_result[5][4]
+ Q=n_76
Xg3556__6417 AO22JIX0 $PINS A=n_31 B=result[0][0] C=n_36 D=am_result[0][0]
+ Q=n_75
Xg3557__5477 AO22JIX0 $PINS A=n_32 B=result[0][1] C=n_37 D=am_result[0][1]
+ Q=n_74
Xg3558__2398 AO22JIX0 $PINS A=n_29 B=result[0][3] C=n_22 D=am_result[0][3]
+ Q=n_73
Xg3559__5107 AO22JIX0 $PINS A=n_30 B=result[0][4] C=n_18 D=am_result[0][4]
+ Q=n_72
Xg3560__6260 ON21JIX0 $PINS A=n_34 B=start C=n_55 Q=n_86
Xg3561__4319 AO22JIX0 $PINS A=n_31 B=result[5][2] C=n_37 D=am_result[5][2]
+ Q=n_71
Xg3562__8428 AO22JIX0 $PINS A=n_32 B=result[1][2] C=n_35 D=am_result[1][2]
+ Q=n_70
Xg3563__5526 AO22JIX0 $PINS A=n_29 B=result[1][4] C=n_22 D=am_result[1][4]
+ Q=n_69
Xg3564__6783 AO22JIX0 $PINS A=n_30 B=result[2][4] C=n_18 D=am_result[2][4]
+ Q=n_68
Xg3565__3680 AO22JIX0 $PINS A=n_31 B=result[2][1] C=n_37 D=am_result[2][1]
+ Q=n_67
Xg3566__1617 AO22JIX0 $PINS A=n_32 B=result[2][2] C=n_35 D=am_result[2][2]
+ Q=n_66
Xg3567__2802 AO22JIX0 $PINS A=n_29 B=result[2][3] C=n_34 D=am_result[2][3]
+ Q=n_65
Xg3568__1705 AO22JIX0 $PINS A=n_30 B=result[1][3] C=n_36 D=am_result[1][3]
+ Q=n_64
Xg3569__5122 AO22JIX0 $PINS A=n_31 B=result[3][0] C=n_37 D=am_result[3][0]
+ Q=n_63
Xg3570__8246 AO22JIX0 $PINS A=n_32 B=result[3][3] C=n_22 D=am_result[3][3]
+ Q=n_62
Xg3571__7098 AO22JIX0 $PINS A=n_29 B=result[3][1] C=n_36 D=am_result[3][1]
+ Q=n_61
Xg3572__6131 AO22JIX0 $PINS A=n_30 B=result[3][4] C=n_20 D=am_result[3][4]
+ Q=n_60
Xg3573__1881 AO22JIX0 $PINS A=n_31 B=result[3][2] C=n_19 D=am_result[3][2]
+ Q=n_59
Xg3574__5115 AO22JIX0 $PINS A=n_29 B=result[4][3] C=n_22 D=am_result[4][3]
+ Q=n_58
Xg3575__7482 AO22JIX0 $PINS A=n_30 B=result[2][0] C=n_36 D=am_result[2][0]
+ Q=n_57
Xg3576__4733 AO22JIX0 $PINS A=n_21 B=result[1][1] C=n_20 D=am_result[1][1]
+ Q=n_56
Xg3577__6161 NA2JIX0 $PINS A=n_48 B=n_34 Q=n_55
Xg3578 INVJIX2 $PINS A=n_45 Q=n_53
Xg3579 INVJIX0 $PINS A=n_44 Q=n_52
Xg3580 INVJIX2 $PINS A=n_54 Q=n_51
Xg3581 INVJIX0 $PINS A=n_43 Q=n_50
Xg3582__9315 AND2JIX1 $PINS A=n_32 B=start Q=n_54
Xg3584 INVJIX0 $PINS A=cycle_counter[1] Q=n_49
Xg3585 INVJIX0 $PINS A=cycle_counter[0] Q=n_48
Xg3586 INVJIX0 $PINS A=n_37 Q=n_47
Xdrc_bufs3587 INVJIX0 $PINS A=n_38 Q=n_45
Xdrc_bufs3588 INVJIX0 $PINS A=n_38 Q=n_44
Xdrc_bufs3589 INVJIX0 $PINS A=n_38 Q=n_43
Xdrc_bufs3590 INVJIX0 $PINS A=n_38 Q=n_42
Xdrc_bufs3591 INVJIX0 $PINS A=n_38 Q=n_41
Xdrc_bufs3592 INVJIX0 $PINS A=n_38 Q=n_40
Xdrc_bufs3593 INVJIX0 $PINS A=n_38 Q=n_39
Xdrc_bufs3594 INVJIX1 $PINS A=n_54 Q=n_38
Xdrc_bufs3600 INVJIX0 $PINS A=n_33 Q=n_37
Xdrc_bufs3601 INVJIX0 $PINS A=n_33 Q=n_36
Xdrc_bufs3602 INVJIX0 $PINS A=n_33 Q=n_35
Xdrc_bufs3603 INVJIX0 $PINS A=n_33 Q=n_34
Xdrc_bufs3604 INVJIX0 $PINS A=en_542 Q=n_33
Xdrc_bufs3608 INVJIX0 $PINS A=n_28 Q=n_32
Xdrc_bufs3609 INVJIX0 $PINS A=n_28 Q=n_31
Xdrc_bufs3610 INVJIX0 $PINS A=n_28 Q=n_30
Xdrc_bufs3611 INVJIX0 $PINS A=n_28 Q=n_29
Xdrc_bufs3612 INVJIX0 $PINS A=n_47 Q=n_28
Xdrc_bufs3617 INVJIX0 $PINS A=n_24 Q=n_27
Xdrc_bufs3618 INVJIX0 $PINS A=n_24 Q=n_26
Xdrc_bufs3619 INVJIX0 $PINS A=n_24 Q=n_25
Xdrc_bufs3620 INVJIX0 $PINS A=n_53 Q=n_24
Xdrc_bufs3625 INVJIX0 $PINS A=n_54 Q=n_23
Xdrc_bufs3631 INVJIX0 $PINS A=n_33 Q=n_22
Xdrc_bufs3639 BUJIX1 $PINS A=n_31 Q=n_21
Xdrc_bufs3644 BUJIX1 $PINS A=n_34 Q=n_20
Xdrc_bufs3649 BUJIX1 $PINS A=n_37 Q=n_19
Xdrc_bufs3654 BUJIX1 $PINS A=n_36 Q=n_18
.ENDS

.SUBCKT adder_nbit_N5 A[4] A[3] A[2] A[1] A[0] B[4] B[3] B[2] B[1] B[0] Sum[5]
+ Sum[4] Sum[3] Sum[2] Sum[1] Sum[0]
Xg294__9945 NA2JIX1 $PINS A=n_30 B=n_8 Q=Sum[5]
Xg295__2883 EO2JIX2 $PINS A=n_29 B=n_15 Q=Sum[4]
Xg296__2346 NA2JIX0 $PINS A=n_29 B=n_10 Q=n_30
Xg297__1666 NA2JIX2 $PINS A=n_27 B=n_7 Q=n_29
Xg298__7410 EO2JIX2 $PINS A=n_26 B=n_18 Q=Sum[3]
Xg299__6417 NA2JIX1 $PINS A=n_26 B=n_11 Q=n_27
Xg300__5477 NA2JIX2 $PINS A=n_24 B=n_5 Q=n_26
Xg301__2398 EO2JIX2 $PINS A=n_23 B=n_17 Q=Sum[2]
Xg302__5107 NA2JIX1 $PINS A=n_23 B=n_14 Q=n_24
Xg303__6260 NA2JIX2 $PINS A=n_21 B=n_6 Q=n_23
Xg304__4319 EO2JIX2 $PINS A=n_16 B=n_20 Q=Sum[1]
Xg305__8428 NA2JIX2 $PINS A=n_20 B=n_13 Q=n_21
Xg306 INJIX2 $PINS A=n_9 Q=n_20
Xg307__5526 NO2I1JIX1 $PINS AN=n_9 B=n_12 Q=Sum[0]
Xg308__6783 EO2JIX0 $PINS A=B[3] B=A[3] Q=n_18
Xg309__3680 EO2JIX1 $PINS A=B[2] B=A[2] Q=n_17
Xg310__1617 EO2JIX2 $PINS A=n_4 B=n_1 Q=n_16
Xg311__2802 EO2JIX0 $PINS A=B[4] B=A[4] Q=n_15
Xg312__1705 OR2JIX0 $PINS A=A[2] B=B[2] Q=n_14
Xg313__5122 NA2JIX1 $PINS A=n_3 B=n_2 Q=n_13
Xg314__8246 NO2JIX0 $PINS A=B[0] B=A[0] Q=n_12
Xg315__7098 OR2JIX0 $PINS A=A[3] B=B[3] Q=n_11
Xg316__6131 OR2JIX0 $PINS A=A[4] B=B[4] Q=n_10
Xg317__1881 NA2JIX0 $PINS A=B[4] B=A[4] Q=n_8
Xg318__5115 NA2JIX0 $PINS A=B[3] B=A[3] Q=n_7
Xg319__7482 NA2JIX1 $PINS A=n_4 B=n_0 Q=n_6
Xg320__4733 NA2JIX0 $PINS A=B[2] B=A[2] Q=n_5
Xg321__6161 NA2JIX1 $PINS A=B[0] B=A[0] Q=n_9
Xg322 INVJIX2 $PINS A=n_3 Q=n_4
Xg323 INVJIX2 $PINS A=B[1] Q=n_3
Xg325 INVJIX2 $PINS A=A[1] Q=n_2
Xfopt INVJIX2 $PINS A=n_2 Q=n_1
Xfopt1 INVJIX0 $PINS A=n_2 Q=n_0
.ENDS

.SUBCKT adder_nbit_N5_158 A[4] A[3] A[2] A[1] A[0] B[4] B[3] B[2] B[1] B[0]
+ Sum[5] Sum[4] Sum[3] Sum[2] Sum[1] Sum[0]
Xg294__9315 NA2JIX1 $PINS A=n_30 B=n_8 Q=Sum[5]
Xg295__9945 EO2JIX2 $PINS A=n_29 B=n_15 Q=Sum[4]
Xg296__2883 NA2JIX0 $PINS A=n_29 B=n_10 Q=n_30
Xg297__2346 NA2JIX2 $PINS A=n_27 B=n_7 Q=n_29
Xg298__1666 EO2JIX2 $PINS A=n_26 B=n_18 Q=Sum[3]
Xg299__7410 NA2JIX1 $PINS A=n_26 B=n_11 Q=n_27
Xg300__6417 NA2JIX2 $PINS A=n_24 B=n_5 Q=n_26
Xg301__5477 EO2JIX2 $PINS A=n_23 B=n_17 Q=Sum[2]
Xg302__2398 NA2JIX1 $PINS A=n_23 B=n_14 Q=n_24
Xg303__5107 NA2JIX2 $PINS A=n_21 B=n_6 Q=n_23
Xg304__6260 EO2JIX2 $PINS A=n_16 B=n_20 Q=Sum[1]
Xg305__4319 NA2JIX2 $PINS A=n_20 B=n_13 Q=n_21
Xg306 INJIX2 $PINS A=n_9 Q=n_20
Xg307__8428 NO2I1JIX1 $PINS AN=n_9 B=n_12 Q=Sum[0]
Xg308__5526 EO2JIX0 $PINS A=B[3] B=A[3] Q=n_18
Xg309__6783 EO2JIX1 $PINS A=B[2] B=A[2] Q=n_17
Xg310__3680 EO2JIX2 $PINS A=n_4 B=n_1 Q=n_16
Xg311__1617 EO2JIX0 $PINS A=B[4] B=A[4] Q=n_15
Xg312__2802 OR2JIX0 $PINS A=A[2] B=B[2] Q=n_14
Xg313__1705 NA2JIX1 $PINS A=n_3 B=n_2 Q=n_13
Xg314__5122 NO2JIX0 $PINS A=B[0] B=A[0] Q=n_12
Xg315__8246 OR2JIX0 $PINS A=A[3] B=B[3] Q=n_11
Xg316__7098 OR2JIX0 $PINS A=A[4] B=B[4] Q=n_10
Xg317__6131 NA2JIX0 $PINS A=B[4] B=A[4] Q=n_8
Xg318__1881 NA2JIX0 $PINS A=B[3] B=A[3] Q=n_7
Xg319__5115 NA2JIX1 $PINS A=n_4 B=n_0 Q=n_6
Xg320__7482 NA2JIX0 $PINS A=B[2] B=A[2] Q=n_5
Xg321__4733 NA2JIX1 $PINS A=B[0] B=A[0] Q=n_9
Xg322 INVJIX2 $PINS A=n_3 Q=n_4
Xg323 INVJIX2 $PINS A=B[1] Q=n_3
Xg325 INVJIX2 $PINS A=A[1] Q=n_2
Xfopt INVJIX2 $PINS A=n_2 Q=n_1
Xfopt1 INVJIX0 $PINS A=n_2 Q=n_0
.ENDS

.SUBCKT adder_nbit_N5_157 A[4] A[3] A[2] A[1] A[0] B[4] B[3] B[2] B[1] B[0]
+ Sum[5] Sum[4] Sum[3] Sum[2] Sum[1] Sum[0]
Xg294__6161 AO22JIX0 $PINS A=n_23 B=n_8 C=B[4] D=A[4] Q=Sum[5]
Xg295__9315 EO2JIX2 $PINS A=n_23 B=n_13 Q=Sum[4]
Xg296__9945 NA2JIX1 $PINS A=n_21 B=n_9 Q=n_23
Xg297__2883 EO2JIX2 $PINS A=n_20 B=n_15 Q=Sum[3]
Xg298__2346 NA2JIX1 $PINS A=n_20 B=n_11 Q=n_21
Xg299__1666 NA2JIX1 $PINS A=n_18 B=n_7 Q=n_20
Xg300__7410 EO2JIX1 $PINS A=n_17 B=n_14 Q=Sum[2]
Xg301__6417 NA2JIX0 $PINS A=n_17 B=n_12 Q=n_18
Xg302__5477 NA2JIX1 $PINS A=n_3 B=n_10 Q=n_17
Xg303__2398 EO3JIX0 $PINS A=n_4 B=B[1] C=A[1] Q=Sum[1]
Xg307__5107 EO2JIX0 $PINS A=B[3] B=A[3] Q=n_15
Xg308__6260 EO2JIX1 $PINS A=n_6 B=n_5 Q=n_14
Xg309__4319 EO2JIX0 $PINS A=B[4] B=A[4] Q=n_13
Xg311__8428 NA2JIX0 $PINS A=n_5 B=n_6 Q=n_12
Xg312__5526 OR2JIX0 $PINS A=A[3] B=B[3] Q=n_11
Xg313__6783 NA2JIX0 $PINS A=B[1] B=A[1] Q=n_10
Xg314__3680 NA2JIX0 $PINS A=B[3] B=A[3] Q=n_9
Xg315__1617 OR2JIX0 $PINS A=A[4] B=B[4] Q=n_8
Xg316__2802 NA2JIX0 $PINS A=B[2] B=A[2] Q=n_7
Xg318 INVJIX1 $PINS A=A[2] Q=n_6
Xg320 INVJIX1 $PINS A=B[2] Q=n_5
Xg2__1705 AND2JIX0 $PINS A=B[0] B=A[0] Q=n_4
Xg323__5122 ON211JIX1 $PINS A=B[1] B=A[1] C=B[0] D=A[0] Q=n_3
Xfopt BUFJIX1 $PINS A=A[0] Q=n_1
Xfopt331 BUFJIX1 $PINS A=B[0] Q=n_0
Xg333__8246 EO2JIX1 $PINS A=n_0 B=n_1 Q=Sum[0]
.ENDS

.SUBCKT adder_nbit_N6 A[5] A[4] A[3] A[2] A[1] A[0] B[5] B[4] B[3] B[2] B[1]
+ B[0] Sum[6] Sum[5] Sum[4] Sum[3] Sum[2] Sum[1] Sum[0]
Xg380__7098 NA2I1JIX1 $PINS AN=n_10 B=n_37 Q=Sum[6]
Xg381__6131 EO2JIX2 $PINS A=n_36 B=n_22 Q=Sum[5]
Xg382__1881 NA2JIX0 $PINS A=n_36 B=n_14 Q=n_37
Xg383__5115 NA2JIX2 $PINS A=n_34 B=n_11 Q=n_36
Xg384__7482 EO2JIX1 $PINS A=n_21 B=n_33 Q=Sum[4]
Xg385__4733 NA2JIX1 $PINS A=n_33 B=n_16 Q=n_34
Xg386__6161 NA2JIX2 $PINS A=n_31 B=n_13 Q=n_33
Xg387__9315 EO2JIX1 $PINS A=n_30 B=n_20 Q=Sum[3]
Xg388__9945 NA2JIX1 $PINS A=n_30 B=n_17 Q=n_31
Xg389__2883 NA2JIX1 $PINS A=n_28 B=n_12 Q=n_30
Xg390__2346 EO2JIX1 $PINS A=n_27 B=n_19 Q=Sum[2]
Xg391__1666 NA2JIX1 $PINS A=n_27 B=n_15 Q=n_28
Xg392__7410 NA2JIX2 $PINS A=n_25 B=n_0 Q=n_27
Xg393__6417 EO2JIX1 $PINS A=n_18 B=n_24 Q=Sum[1]
Xg394__5477 NA2JIX1 $PINS A=n_1 B=n_24 Q=n_25
Xg395__2398 HAJIX1 $PINS A=A[0] B=B[0] CO=n_24 S=Sum[0]
Xg396__5107 EO2JIX0 $PINS A=B[5] B=A[5] Q=n_22
Xg397__6260 EO2JIX1 $PINS A=B[4] B=A[4] Q=n_21
Xg398__4319 EO2JIX2 $PINS A=B[3] B=A[3] Q=n_20
Xg399__8428 EO2JIX2 $PINS A=B[2] B=A[2] Q=n_19
Xg400__5526 EO2JIX2 $PINS A=n_7 B=n_9 Q=n_18
Xg401__6783 NA2I1JIX1 $PINS AN=B[3] B=n_4 Q=n_17
Xg403__3680 NA2JIX0 $PINS A=n_3 B=n_5 Q=n_16
Xg404__1617 NA2I1JIX1 $PINS AN=B[2] B=n_2 Q=n_15
Xg405__2802 OR2JIX0 $PINS A=A[5] B=B[5] Q=n_14
Xg406__1705 NA2JIX0 $PINS A=B[3] B=A[3] Q=n_13
Xg407__5122 NA2JIX0 $PINS A=B[2] B=A[2] Q=n_12
Xg408__8246 NA2JIX0 $PINS A=B[4] B=A[4] Q=n_11
Xg410__7098 AND2JIX0 $PINS A=B[5] B=A[5] Q=n_10
Xg413 INVJIX1 $PINS A=n_8 Q=n_9
Xg414 INVJIX1 $PINS A=A[1] Q=n_8
Xg415 INJIX2 $PINS A=n_6 Q=n_7
Xg417 INVJIX1 $PINS A=B[1] Q=n_6
Xg418 INVJIX0 $PINS A=A[4] Q=n_5
Xg419 INVJIX0 $PINS A=A[3] Q=n_4
Xg420 INVJIX0 $PINS A=B[4] Q=n_3
Xg421 INVJIX0 $PINS A=A[2] Q=n_2
Xg2__6131 NA2I1JIX1 $PINS AN=A[1] B=n_6 Q=n_1
Xg422__1881 NA2I1JIX2 $PINS AN=n_8 B=n_7 Q=n_0
.ENDS

.SUBCKT adder_nbit_N6_1 A[5] A[4] A[3] A[2] A[1] A[0] B[5] B[4] B[3] B[2] B[1]
+ B[0] Sum[6] Sum[5] Sum[4] Sum[3] Sum[2] Sum[1] Sum[0]
*.CONNECT Sum[0] VSS
Xg66 BUJIX1 $PINS A=A[1] Q=n_15
Xg72__5115 EO2JIX1 $PINS A=n_15 B=B[1] Q=Sum[1]
Xg83__7482 EO2JIX2 $PINS A=n_14 B=n_13 Q=Sum[2]
Xg84__4733 EN2JIX0 $PINS A=A[2] B=B[2] Q=n_14
Xg85 BUFJIX1 $PINS A=n_16 Q=n_13
Xg86__6161 NA2JIX1 $PINS A=A[1] B=B[1] Q=n_16
Xg156__9315 NA2JIX1 $PINS A=n_3 B=n_12 Q=Sum[5]
Xg157 BUFJIX1 $PINS A=n_3 Q=Sum[6]
Xg159__9945 NA2JIX0 $PINS A=n_11 B=A[5] Q=n_12
Xg160__2883 NA2JIX0 $PINS A=n_10 B=n_4 Q=n_11
Xg161__2346 EO2JIX2 $PINS A=n_9 B=n_6 Q=Sum[4]
Xg162__1666 ON21JIX1 $PINS A=A[4] B=B[4] C=n_8 Q=n_10
Xg163 BUFJIX2 $PINS A=n_8 Q=n_9
Xg164__7410 NA2JIX1 $PINS A=n_7 B=n_5 Q=n_8
Xg165__6417 ON21JIX1 $PINS A=A[3] B=B[3] C=Carry[3] Q=n_7
Xg166__5477 EO2JIX2 $PINS A=A[4] B=B[4] Q=n_6
Xg167__2398 NA2JIX0 $PINS A=A[3] B=B[3] Q=n_5
Xg168__5107 NA2JIX0 $PINS A=A[4] B=B[4] Q=n_4
Xg2__6260 NA3I1JIX0 $PINS AN=A[5] B=n_10 C=n_4 Q=n_3
Xg109__4319 EO2JIX1 $PINS A=n_2 B=Carry[3] Q=Sum[3]
Xg111__8428 ON21JIX1 $PINS A=n_1 B=n_16 C=n_0 Q=Carry[3]
Xg112__5526 EO2JIX2 $PINS A=A[3] B=B[3] Q=n_2
Xg113__6783 NO2JIX1 $PINS A=A[2] B=B[2] Q=n_1
Xg114__3680 NA2JIX1 $PINS A=A[2] B=B[2] Q=n_0
.ENDS

.SUBCKT adder_nbit_N7 A[6] A[5] A[4] A[3] A[2] A[1] A[0] B[6] B[5] B[4] B[3]
+ B[2] B[1] B[0] Sum[7] Sum[6] Sum[5] Sum[4] Sum[3] Sum[2] Sum[1] Sum[0]
Xg138__1617 EO2JIX0 $PINS A=A[0] B=B[0] Q=Sum[0]
Xg149__2802 EN3JIX0 $PINS A=A[1] B=B[1] C=n_24 Q=Sum[1]
Xg150__1705 NA2JIX0 $PINS A=A[0] B=B[0] Q=n_24
Xg175__5122 EO3JIX0 $PINS A=n_23 B=A[2] C=B[2] Q=Sum[2]
Xg176 BUJIX1 $PINS A=Carry[2] Q=n_23
Xg177__8246 ON21JIX1 $PINS A=n_22 B=n_24 C=n_21 Q=Carry[2]
Xg178__7098 NO2JIX1 $PINS A=B[1] B=A[1] Q=n_22
Xg179__6131 NA2JIX0 $PINS A=A[1] B=B[1] Q=n_21
Xg180__1881 EO3JIX0 $PINS A=Carry[3] B=A[3] C=B[3] Q=Sum[3]
Xg181__5115 NA2JIX2 $PINS A=n_20 B=n_19 Q=Carry[3]
Xg182__7482 NA2JIX1 $PINS A=n_18 B=Carry[2] Q=n_20
Xg183__4733 NA2JIX0 $PINS A=A[2] B=B[2] Q=n_19
Xg2__6161 OR2JIX0 $PINS A=A[2] B=B[2] Q=n_18
Xg291__9315 NA2JIX1 $PINS A=n_17 B=n_5 Q=Sum[7]
Xg292__9945 EO2JIX1 $PINS A=n_16 B=n_10 Q=Sum[6]
Xg293__2883 NA2JIX0 $PINS A=n_4 B=n_16 Q=n_17
Xg294__2346 NA2JIX1 $PINS A=n_15 B=n_3 Q=n_16
Xg295__1666 EO2JIX0 $PINS A=n_12 B=n_14 Q=Sum[5]
Xg296__7410 ON21JIX1 $PINS A=B[5] B=A[5] C=n_14 Q=n_15
Xg297__6417 ON21JIX2 $PINS A=n_9 B=n_13 C=n_6 Q=n_14
Xg298__5477 EN2JIX0 $PINS A=n_11 B=n_13 Q=Sum[4]
Xg299__2398 AN21JIX2 $PINS A=Carry[3] B=n_7 C=n_8 Q=n_13
Xg300__5107 EO2JIX0 $PINS A=A[5] B=B[5] Q=n_12
Xg301__6260 EO2JIX0 $PINS A=A[4] B=n_0 Q=n_11
Xg302__4319 EO2JIX1 $PINS A=A[6] B=B[6] Q=n_10
Xg303__8428 NO2JIX1 $PINS A=A[4] B=B[4] Q=n_9
Xg304__5526 AND2JIX0 $PINS A=A[3] B=B[3] Q=n_8
Xg305__6783 NA2JIX1 $PINS A=n_1 B=n_2 Q=n_7
Xg306__3680 NA2JIX0 $PINS A=A[4] B=B[4] Q=n_6
Xg307__1617 NA2JIX0 $PINS A=A[6] B=B[6] Q=n_5
Xg308__2802 OR2JIX0 $PINS A=A[6] B=B[6] Q=n_4
Xg309__1705 NA2JIX0 $PINS A=A[5] B=B[5] Q=n_3
Xg310 INVJIX0 $PINS A=B[3] Q=n_2
Xg311 INVJIX0 $PINS A=A[3] Q=n_1
Xg312 BUFJIX1 $PINS A=B[4] Q=n_0
.ENDS

.SUBCKT AdderTree_6_WEIGHT_WIDTH8_NUM_UNITS6 input_data[0][7] input_data[0][6]
+ input_data[0][5] input_data[0][4] input_data[0][3] input_data[0][2]
+ input_data[0][1] input_data[0][0] input_data[1][7] input_data[1][6]
+ input_data[1][5] input_data[1][4] input_data[1][3] input_data[1][2]
+ input_data[1][1] input_data[1][0] input_data[2][7] input_data[2][6]
+ input_data[2][5] input_data[2][4] input_data[2][3] input_data[2][2]
+ input_data[2][1] input_data[2][0] input_data[3][7] input_data[3][6]
+ input_data[3][5] input_data[3][4] input_data[3][3] input_data[3][2]
+ input_data[3][1] input_data[3][0] input_data[4][7] input_data[4][6]
+ input_data[4][5] input_data[4][4] input_data[4][3] input_data[4][2]
+ input_data[4][1] input_data[4][0] input_data[5][7] input_data[5][6]
+ input_data[5][5] input_data[5][4] input_data[5][3] input_data[5][2]
+ input_data[5][1] input_data[5][0] clk rst sum_combinational[10]
+ sum_combinational[9] sum_combinational[8] sum_combinational[7]
+ sum_combinational[6] sum_combinational[5] sum_combinational[4]
+ sum_combinational[3] sum_combinational[2] sum_combinational[1]
+ sum_combinational[0] DFT_/sen DFT_/sdo
*.CONNECT sum_combinational[0] VSS
*.CONNECT sum_combinational[1] VSS
*.CONNECT sum_combinational[2] VSS
*.CONNECT sum_combinational[3] VSS
*.CONNECT sum_combinational[8] VSS
*.CONNECT sum_combinational[9] VSS
*.CONNECT sum_combinational[10] VSS
XL1_ADD[0].inst_L1 adder_nbit_N5 $PINS A[4]=input_data[0][4]
+ A[3]=input_data[0][3] A[2]=input_data[0][2] A[1]=input_data[0][1]
+ A[0]=input_data[0][0] B[4]=input_data[1][4] B[3]=input_data[1][3]
+ B[2]=input_data[1][2] B[1]=input_data[1][1] B[0]=input_data[1][0]
+ Sum[5]=int_sum_L1[0][5] Sum[4]=int_sum_L1[0][4] Sum[3]=int_sum_L1[0][3]
+ Sum[2]=int_sum_L1[0][2] Sum[1]=int_sum_L1[0][1] Sum[0]=int_sum_L1[0][0]
XL1_ADD[1].inst_L1 adder_nbit_N5_158 $PINS A[4]=input_data[2][4]
+ A[3]=input_data[2][3] A[2]=input_data[2][2] A[1]=input_data[2][1]
+ A[0]=input_data[2][0] B[4]=input_data[3][4] B[3]=input_data[3][3]
+ B[2]=input_data[3][2] B[1]=input_data[3][1] B[0]=input_data[3][0]
+ Sum[5]=int_sum_L1[1][5] Sum[4]=int_sum_L1[1][4] Sum[3]=int_sum_L1[1][3]
+ Sum[2]=int_sum_L1[1][2] Sum[1]=int_sum_L1[1][1] Sum[0]=int_sum_L1[1][0]
XL1_ADD[2].inst_L1 adder_nbit_N5_157 $PINS A[4]=input_data[4][4]
+ A[3]=input_data[4][3] A[2]=input_data[4][2] A[1]=input_data[4][1]
+ A[0]=input_data[4][0] B[4]=input_data[5][4] B[3]=input_data[5][3]
+ B[2]=input_data[5][2] B[1]=input_data[5][1] B[0]=input_data[5][0]
+ Sum[5]=int_sum_L1[2][5] Sum[4]=int_sum_L1[2][4] Sum[3]=int_sum_L1[2][3]
+ Sum[2]=int_sum_L1[2][2] Sum[1]=int_sum_L1[2][1] Sum[0]=int_sum_L1[2][0]
Xinst_L2 adder_nbit_N6 $PINS A[5]=int_sum_L1[0][5] A[4]=int_sum_L1[0][4]
+ A[3]=int_sum_L1[0][3] A[2]=int_sum_L1[0][2] A[1]=int_sum_L1[0][1]
+ A[0]=int_sum_L1[0][0] B[5]=int_sum_L1[1][5] B[4]=int_sum_L1[1][4]
+ B[3]=int_sum_L1[1][3] B[2]=int_sum_L1[1][2] B[1]=int_sum_L1[1][1]
+ B[0]=int_sum_L1[1][0] Sum[6]=int_sum_L2[0][6] Sum[5]=int_sum_L2[0][5]
+ Sum[4]=int_sum_L2[0][4] Sum[3]=int_sum_L2[0][3] Sum[2]=int_sum_L2[0][2]
+ Sum[1]=int_sum_L2[0][1] Sum[0]=int_sum_L2[0][0]
Xinst_L2_extra adder_nbit_N6_1 $PINS A[5]=int_sum_L1[2][5]
+ A[4]=int_sum_L1[2][4] A[3]=int_sum_L1[2][3] A[2]=int_sum_L1[2][2]
+ A[1]=int_sum_L1[2][1] A[0]=VSS B[5]=VDD B[4]=DFT_/sdo B[3]=sum_out[2]
+ B[2]=sum_out[1] B[1]=sum_out[0] B[0]=VSS Sum[6]=int_sum_L2[1][6]
+ Sum[5]=int_sum_L2[1][5] Sum[4]=int_sum_L2[1][4] Sum[3]=int_sum_L2[1][3]
+ Sum[2]=int_sum_L2[1][2] Sum[1]=int_sum_L2[1][1] Sum[0]=UNCONNECTED
Xinst_L6_0 adder_nbit_N7 $PINS A[6]=int_sum_L2[0][6] A[5]=int_sum_L2[0][5]
+ A[4]=int_sum_L2[0][4] A[3]=int_sum_L2[0][3] A[2]=int_sum_L2[0][2]
+ A[1]=int_sum_L2[0][1] A[0]=int_sum_L2[0][0] B[6]=int_sum_L2[1][6]
+ B[5]=int_sum_L2[1][5] B[4]=int_sum_L2[1][4] B[3]=int_sum_L2[1][3]
+ B[2]=int_sum_L2[1][2] B[1]=int_sum_L2[1][1] B[0]=int_sum_L1[2][0]
+ Sum[7]=sum_combinational[7] Sum[6]=sum_combinational[6]
+ Sum[5]=sum_combinational[5] Sum[4]=sum_combinational[4] Sum[3]=n_40 Sum[2]=n_41
+ Sum[1]=n_42 Sum[0]=n_43
Xsum_out_reg[3] SDFRQJIX1 $PINS C=clk D=n_3 SD=sum_out[2] SE=DFT_/sen
+ Q=DFT_/sdo
Xg9__5122 NO2I1JIX0 $PINS AN=n_40 B=rst Q=n_3
Xsum_out_reg[2] SDFRQJIX1 $PINS C=clk D=n_2 SD=sum_out[1] SE=DFT_/sen
+ Q=sum_out[2]
Xg11__8246 NO2I1JIX0 $PINS AN=n_41 B=rst Q=n_2
Xsum_out_reg[1] SDFRQJIX1 $PINS C=clk D=n_1 SD=sum_out[0] SE=DFT_/sen
+ Q=sum_out[1]
Xg13__7098 NO2I1JIX0 $PINS AN=n_42 B=rst Q=n_1
Xsum_out_reg[0] SDFRQJIX1 $PINS C=clk D=n_0 SD=input_data[5][4] SE=DFT_/sen
+ Q=sum_out[0]
Xg15__6131 NO2I1JIX0 $PINS AN=n_43 B=rst Q=n_0
.ENDS

.SUBCKT Out_Gen_Func clk reset IN[3] IN[2] IN[1] IN[0] z_p z_n DFT_/sdi
+ DFT_/sen
XR3_reg SDFRRQJIX1 $PINS RN=n_1 C=clk D=n_13 SD=R2 SE=DFT_/sen Q=z_n
Xg253__1881 NA2JIX2 $PINS A=n_12 B=n_0 Q=z_p
Xg254__5115 EO2JIX0 $PINS A=n_9 B=n_11 Q=n_13
Xg255__7482 NA2JIX0 $PINS A=n_9 B=n_10 Q=n_12
Xg256__4733 EO2JIX0 $PINS A=IN[3] B=R2 Q=n_11
Xg257__6161 NA2I1JIX0 $PINS AN=R2 B=n_2 Q=n_10
XR2_reg SDFRRQJIX1 $PINS RN=n_1 C=clk D=n_8 SD=R1 SE=DFT_/sen Q=R2
Xg260__9315 ON21JIX1 $PINS A=n_7 B=n_3 C=n_6 Q=n_9
Xg261__9945 EN3JIX0 $PINS A=n_3 B=IN[2] C=R1 Q=n_8
Xg262__2883 NO2JIX1 $PINS A=IN[2] B=R1 Q=n_7
Xg263__2346 NA2JIX0 $PINS A=IN[2] B=R1 Q=n_6
XR1_reg SDFRRQJIX1 $PINS RN=n_1 C=clk D=n_5 SD=R0 SE=DFT_/sen Q=R1
Xg265__1666 NO2I1JIX0 $PINS AN=n_3 B=n_4 Q=n_5
Xg266__7410 NO2JIX0 $PINS A=IN[1] B=R0 Q=n_4
Xg267__6417 NA2JIX1 $PINS A=IN[1] B=R0 Q=n_3
XR0_reg SDFRRQJIX1 $PINS RN=n_1 C=clk D=IN[0] SD=DFT_/sdi SE=DFT_/sen Q=R0
Xg270 INVJIX0 $PINS A=IN[3] Q=n_2
Xg271 INVJIX0 $PINS A=reset Q=n_1
Xg2__5477 NA2I1JIX0 $PINS AN=n_2 B=R2 Q=n_0
.ENDS

.SUBCKT Main weight[0][7] weight[0][6] weight[0][5] weight[0][4] weight[0][3]
+ weight[0][2] weight[0][1] weight[0][0] weight[1][7] weight[1][6] weight[1][5]
+ weight[1][4] weight[1][3] weight[1][2] weight[1][1] weight[1][0] weight[2][7]
+ weight[2][6] weight[2][5] weight[2][4] weight[2][3] weight[2][2] weight[2][1]
+ weight[2][0] weight[3][7] weight[3][6] weight[3][5] weight[3][4] weight[3][3]
+ weight[3][2] weight[3][1] weight[3][0] weight[4][7] weight[4][6] weight[4][5]
+ weight[4][4] weight[4][3] weight[4][2] weight[4][1] weight[4][0] weight[5][7]
+ weight[5][6] weight[5][5] weight[5][4] weight[5][3] weight[5][2] weight[5][1]
+ weight[5][0] activation[0][7] activation[0][6] activation[0][5]
+ activation[0][4] activation[0][3] activation[0][2] activation[0][1]
+ activation[0][0] activation[1][7] activation[1][6] activation[1][5]
+ activation[1][4] activation[1][3] activation[1][2] activation[1][1]
+ activation[1][0] activation[2][7] activation[2][6] activation[2][5]
+ activation[2][4] activation[2][3] activation[2][2] activation[2][1]
+ activation[2][0] activation[3][7] activation[3][6] activation[3][5]
+ activation[3][4] activation[3][3] activation[3][2] activation[3][1]
+ activation[3][0] activation[4][7] activation[4][6] activation[4][5]
+ activation[4][4] activation[4][3] activation[4][2] activation[4][1]
+ activation[4][0] activation[5][7] activation[5][6] activation[5][5]
+ activation[5][4] activation[5][3] activation[5][2] activation[5][1]
+ activation[5][0] start clk rst en z_p z_n scan_en scan_in scan_out
*.CONNECT scan_out z_n
XA6M ActivationMultiplier_6_IN_WIDTH8_NUM_UNITS6_ACTIVATION_WIDTH8 $PINS
+ activation[0][7]=activation[0][7] activation[0][6]=activation[0][6]
+ activation[0][5]=activation[0][5] activation[0][4]=activation[0][4]
+ activation[0][3]=activation[0][3] activation[0][2]=activation[0][2]
+ activation[0][1]=activation[0][1] activation[0][0]=activation[0][0]
+ activation[1][7]=activation[1][7] activation[1][6]=activation[1][6]
+ activation[1][5]=activation[1][5] activation[1][4]=activation[1][4]
+ activation[1][3]=activation[1][3] activation[1][2]=activation[1][2]
+ activation[1][1]=activation[1][1] activation[1][0]=activation[1][0]
+ activation[2][7]=activation[2][7] activation[2][6]=activation[2][6]
+ activation[2][5]=activation[2][5] activation[2][4]=activation[2][4]
+ activation[2][3]=activation[2][3] activation[2][2]=activation[2][2]
+ activation[2][1]=activation[2][1] activation[2][0]=activation[2][0]
+ activation[3][7]=activation[3][7] activation[3][6]=activation[3][6]
+ activation[3][5]=activation[3][5] activation[3][4]=activation[3][4]
+ activation[3][3]=activation[3][3] activation[3][2]=activation[3][2]
+ activation[3][1]=activation[3][1] activation[3][0]=activation[3][0]
+ activation[4][7]=activation[4][7] activation[4][6]=activation[4][6]
+ activation[4][5]=activation[4][5] activation[4][4]=activation[4][4]
+ activation[4][3]=activation[4][3] activation[4][2]=activation[4][2]
+ activation[4][1]=activation[4][1] activation[4][0]=activation[4][0]
+ activation[5][7]=activation[5][7] activation[5][6]=activation[5][6]
+ activation[5][5]=activation[5][5] activation[5][4]=activation[5][4]
+ activation[5][3]=activation[5][3] activation[5][2]=activation[5][2]
+ activation[5][1]=activation[5][1] activation[5][0]=activation[5][0]
+ weight[0][7]=weight[0][7] weight[0][6]=weight[0][6] weight[0][5]=weight[0][5]
+ weight[0][4]=weight[0][4] weight[0][3]=weight[0][3] weight[0][2]=weight[0][2]
+ weight[0][1]=weight[0][1] weight[0][0]=weight[0][0] weight[1][7]=weight[1][7]
+ weight[1][6]=weight[1][6] weight[1][5]=weight[1][5] weight[1][4]=weight[1][4]
+ weight[1][3]=weight[1][3] weight[1][2]=weight[1][2] weight[1][1]=weight[1][1]
+ weight[1][0]=weight[1][0] weight[2][7]=weight[2][7] weight[2][6]=weight[2][6]
+ weight[2][5]=weight[2][5] weight[2][4]=weight[2][4] weight[2][3]=weight[2][3]
+ weight[2][2]=weight[2][2] weight[2][1]=weight[2][1] weight[2][0]=weight[2][0]
+ weight[3][7]=weight[3][7] weight[3][6]=weight[3][6] weight[3][5]=weight[3][5]
+ weight[3][4]=weight[3][4] weight[3][3]=weight[3][3] weight[3][2]=weight[3][2]
+ weight[3][1]=weight[3][1] weight[3][0]=weight[3][0] weight[4][7]=weight[4][7]
+ weight[4][6]=weight[4][6] weight[4][5]=weight[4][5] weight[4][4]=weight[4][4]
+ weight[4][3]=weight[4][3] weight[4][2]=weight[4][2] weight[4][1]=weight[4][1]
+ weight[4][0]=weight[4][0] weight[5][7]=weight[5][7] weight[5][6]=weight[5][6]
+ weight[5][5]=weight[5][5] weight[5][4]=weight[5][4] weight[5][3]=weight[5][3]
+ weight[5][2]=weight[5][2] weight[5][1]=weight[5][1] weight[5][0]=weight[5][0]
+ clk=clk rst=rst start=start result[0][7]=result[0][7] result[0][6]=result[0][6]
+ result[0][5]=result[0][5] result[0][4]=result[0][4] result[0][3]=result[0][3]
+ result[0][2]=result[0][2] result[0][1]=result[0][1] result[0][0]=result[0][0]
+ result[1][7]=result[1][7] result[1][6]=result[1][6] result[1][5]=result[1][5]
+ result[1][4]=result[1][4] result[1][3]=result[1][3] result[1][2]=result[1][2]
+ result[1][1]=result[1][1] result[1][0]=result[1][0] result[2][7]=result[2][7]
+ result[2][6]=result[2][6] result[2][5]=result[2][5] result[2][4]=result[2][4]
+ result[2][3]=result[2][3] result[2][2]=result[2][2] result[2][1]=result[2][1]
+ result[2][0]=result[2][0] result[3][7]=result[3][7] result[3][6]=result[3][6]
+ result[3][5]=result[3][5] result[3][4]=result[3][4] result[3][3]=result[3][3]
+ result[3][2]=result[3][2] result[3][1]=result[3][1] result[3][0]=result[3][0]
+ result[4][7]=result[4][7] result[4][6]=result[4][6] result[4][5]=result[4][5]
+ result[4][4]=result[4][4] result[4][3]=result[4][3] result[4][2]=result[4][2]
+ result[4][1]=result[4][1] result[4][0]=result[4][0] result[5][7]=result[5][7]
+ result[5][6]=result[5][6] result[5][5]=result[5][5] result[5][4]=result[5][4]
+ result[5][3]=result[5][3] result[5][2]=result[5][2] result[5][1]=result[5][1]
+ result[5][0]=result[5][0] en=en DFT_/sdi=scan_in DFT_/sen=scan_en
XAT6 AdderTree_6_WEIGHT_WIDTH8_NUM_UNITS6 $PINS input_data[0][7]=VSS
+ input_data[0][6]=VSS input_data[0][5]=VSS input_data[0][4]=result[0][4]
+ input_data[0][3]=result[0][3] input_data[0][2]=result[0][2]
+ input_data[0][1]=result[0][1] input_data[0][0]=result[0][0]
+ input_data[1][7]=VSS input_data[1][6]=VSS input_data[1][5]=VSS
+ input_data[1][4]=result[1][4] input_data[1][3]=result[1][3]
+ input_data[1][2]=result[1][2] input_data[1][1]=result[1][1]
+ input_data[1][0]=result[1][0] input_data[2][7]=VSS input_data[2][6]=VSS
+ input_data[2][5]=VSS input_data[2][4]=result[2][4]
+ input_data[2][3]=result[2][3] input_data[2][2]=result[2][2]
+ input_data[2][1]=result[2][1] input_data[2][0]=result[2][0]
+ input_data[3][7]=VSS input_data[3][6]=VSS input_data[3][5]=VSS
+ input_data[3][4]=result[3][4] input_data[3][3]=result[3][3]
+ input_data[3][2]=result[3][2] input_data[3][1]=result[3][1]
+ input_data[3][0]=result[3][0] input_data[4][7]=VSS input_data[4][6]=VSS
+ input_data[4][5]=VSS input_data[4][4]=result[4][4]
+ input_data[4][3]=result[4][3] input_data[4][2]=result[4][2]
+ input_data[4][1]=result[4][1] input_data[4][0]=result[4][0]
+ input_data[5][7]=VSS input_data[5][6]=VSS input_data[5][5]=VSS
+ input_data[5][4]=result[5][4] input_data[5][3]=result[5][3]
+ input_data[5][2]=result[5][2] input_data[5][1]=result[5][1]
+ input_data[5][0]=result[5][0] clk=clk rst=rst
+ sum_combinational[10]=sum_combinational[10]
+ sum_combinational[9]=sum_combinational[9]
+ sum_combinational[8]=sum_combinational[8]
+ sum_combinational[7]=sum_combinational[7]
+ sum_combinational[6]=sum_combinational[6]
+ sum_combinational[5]=sum_combinational[5]
+ sum_combinational[4]=sum_combinational[4]
+ sum_combinational[3]=sum_combinational[3]
+ sum_combinational[2]=sum_combinational[2]
+ sum_combinational[1]=sum_combinational[1]
+ sum_combinational[0]=sum_combinational[0] DFT_/sen=scan_en DFT_/sdo=n_105
XOGF Out_Gen_Func $PINS clk=clk reset=rst IN[3]=sum_combinational[7]
+ IN[2]=sum_combinational[6] IN[1]=sum_combinational[5]
+ IN[0]=sum_combinational[4] z_p=z_p z_n=z_n DFT_/sdi=n_105 DFT_/sen=scan_en
.ENDS
.GLOBAL VDD
.GLOBAL VSS
