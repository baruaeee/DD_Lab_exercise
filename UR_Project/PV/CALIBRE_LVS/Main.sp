* SPICE NETLIST
***************************************

.SUBCKT ptap1 TIE SUB
.ENDS
***************************************
.SUBCKT ntap1 TIE WELL
.ENDS
***************************************
.SUBCKT pnpMPA PLUS MINUS TIE
.ENDS
***************************************
.SUBCKT pdnw bn MINUS
.ENDS
***************************************
.SUBCKT schottky_nbl1 PLUS MINUS TIE
.ENDS
***************************************
.SUBCKT rfcmim PLUS MINUS TIE
.ENDS
***************************************
.SUBCKT sg13_hv_svaricap G1 W G2 bn
.ENDS
***************************************
.SUBCKT diodevdd_2kv VDD PAD VSS
.ENDS
***************************************
.SUBCKT idiodevdd_2kv VDD PAD VSS
.ENDS
***************************************
.SUBCKT diodevdd_4kv VDD PAD VSS
.ENDS
***************************************
.SUBCKT idiodevdd_4kv VDD PAD VSS
.ENDS
***************************************
.SUBCKT diodevss_2kv VDD PAD VSS
.ENDS
***************************************
.SUBCKT idiodevss_2kv VDD PAD VSS
.ENDS
***************************************
.SUBCKT diodevss_4kv VDD PAD VSS
.ENDS
***************************************
.SUBCKT idiodevss_4kv VDD PAD VSS
.ENDS
***************************************
.SUBCKT isolbox S I bn
.ENDS
***************************************
.SUBCKT TL1 CG T1 T2
.ENDS
***************************************
.SUBCKT TL1_90deg CG T1 T2
.ENDS
***************************************
.SUBCKT TL1_T CG T1 T2 T3
.ENDS
***************************************
.SUBCKT TL1_Y CG T1 T2 T3
.ENDS
***************************************
.SUBCKT TL2 CG T2 T3
.ENDS
***************************************
.SUBCKT TL2_45deg CG T1 T2 T3 T4
.ENDS
***************************************
.SUBCKT TL2_90deg CG T1 T2 T3 T4
.ENDS
***************************************
.SUBCKT dummy1 C
.ENDS
***************************************
.SUBCKT iprobe PLUS MINUS
.ENDS
***************************************
.SUBCKT diffstbprobe IN1 IN2 OUT1 OUT2
.ENDS
***************************************
.SUBCKT otpcell G D B
.ENDS
***************************************
.SUBCKT TSV Top BackSide
.ENDS
***************************************
.SUBCKT l2_ind_lvs LA LB bn
.ENDS
***************************************
.SUBCKT inductor LA LB bn
.ENDS
***************************************
.SUBCKT inductor3 LA LB LC bn
.ENDS
***************************************
.SUBCKT pad Core_Con Pad_Con
.ENDS
***************************************
.SUBCKT viagen12_CDNS_754739516580
** N=3 EP=0 IP=0 FDC=0
.ENDS
***************************************
.SUBCKT viagen23_CDNS_754739516581
** N=3 EP=0 IP=0 FDC=0
.ENDS
***************************************
.SUBCKT viagen67_CDNS_7547395165811
** N=3 EP=0 IP=0 FDC=0
.ENDS
***************************************
.SUBCKT viagen23_CDNS_7547395165815
** N=3 EP=0 IP=0 FDC=0
.ENDS
***************************************
.SUBCKT viagen34_CDNS_7547395165814
** N=3 EP=0 IP=0 FDC=0
.ENDS
***************************************
.SUBCKT viagen12_CDNS_7547395165816
** N=3 EP=0 IP=0 FDC=0
.ENDS
***************************************
.SUBCKT viagen45_CDNS_7547395165813
** N=3 EP=0 IP=0 FDC=0
.ENDS
***************************************
.SUBCKT viagen56_CDNS_7547395165812
** N=3 EP=0 IP=0 FDC=0
.ENDS
***************************************
.SUBCKT ICV_1
** N=3 EP=0 IP=15 FDC=0
.ENDS
***************************************
.SUBCKT FEED1JI
** N=4 EP=0 IP=0 FDC=0
.ENDS
***************************************
.SUBCKT FEED2JI
** N=4 EP=0 IP=0 FDC=0
.ENDS
***************************************
.SUBCKT DECAP3JI 1 2
** N=5 EP=2 IP=0 FDC=2
M0 4 5 1 1 sg13_lv_pmos w=1.21e-06 l=4.5e-07 as=3.626e-13 ad=4.114e-13 ps=3.54e-06 pd=3.1e-06 m=1 ng=1 $X=365 $Y=2100 $D=6
M1 2 4 5 2 sg13_lv_nmos w=8.8e-07 l=4.5e-07 as=2.992e-13 ad=2.768e-13 ps=2.44e-06 pd=2.88e-06 m=1 ng=1 $X=445 $Y=470 $D=10
.ENDS
***************************************
.SUBCKT FEED3JI
** N=4 EP=0 IP=0 FDC=0
.ENDS
***************************************
.SUBCKT DECAP5JI 1 2
** N=5 EP=2 IP=0 FDC=4
M0 1 5 1 1 sg13_lv_pmos w=1.34e-06 l=7.15e-07 as=3.8e-13 ad=2.44e-13 ps=3.78e-06 pd=1.97e-06 m=1 ng=1 $X=355 $Y=1970 $D=6
M1 4 5 1 1 sg13_lv_pmos w=1.18e-06 l=1.3e-07 as=2.44e-13 ad=5.487e-13 ps=1.97e-06 pd=3.29e-06 m=1 ng=1 $X=1400 $Y=2130 $D=6
M2 2 4 5 2 sg13_lv_nmos w=7.6e-07 l=1.3e-07 as=3.534e-13 ad=1.695e-13 ps=2.45e-06 pd=1.51e-06 m=1 ng=1 $X=570 $Y=470 $D=10
M3 2 4 2 2 sg13_lv_nmos w=8.8e-07 l=7.15e-07 as=1.695e-13 ad=2.65e-13 ps=1.51e-06 pd=2.86e-06 m=1 ng=1 $X=1030 $Y=470 $D=10
.ENDS
***************************************
.SUBCKT BUJIX1 1 2 3 4
** N=6 EP=4 IP=0 FDC=4
M0 1 4 6 1 sg13_lv_pmos w=7.5e-07 l=1.3e-07 as=2.55e-13 ad=5.575e-13 ps=2.18e-06 pd=2.74e-06 m=1 ng=1 $X=445 $Y=1970 $D=6
M1 2 6 1 1 sg13_lv_pmos w=1.34e-06 l=1.3e-07 as=5.575e-13 ad=4.556e-13 ps=2.74e-06 pd=3.36e-06 m=1 ng=1 $X=1105 $Y=1970 $D=6
M2 3 4 6 3 sg13_lv_nmos w=3e-07 l=1.3e-07 as=1.02e-13 ad=4.757e-13 ps=1.28e-06 pd=2.79e-06 m=1 ng=1 $X=445 $Y=900 $D=10
M3 2 6 3 3 sg13_lv_nmos w=6.1e-07 l=1.3e-07 as=4.757e-13 ad=2.074e-13 ps=2.79e-06 pd=1.9e-06 m=1 ng=1 $X=1105 $Y=740 $D=10
.ENDS
***************************************
.SUBCKT ICV_2
** N=3 EP=0 IP=6 FDC=0
.ENDS
***************************************
.SUBCKT FEED5JI
** N=4 EP=0 IP=0 FDC=0
.ENDS
***************************************
.SUBCKT AO22JIX0 1 2 3 4 5 6 7
** N=12 EP=7 IP=0 FDC=10
M0 2 9 1 2 sg13_lv_pmos w=6.7e-07 l=1.3e-07 as=2.278e-13 ad=3.8425e-13 ps=2.02e-06 pd=2.46243e-06 m=1 ng=1 $X=445 $Y=2050 $D=6
M1 10 4 2 2 sg13_lv_pmos w=6.7e-07 l=1.3e-07 as=3.8425e-13 ad=2.9485e-13 ps=2.46243e-06 pd=2.255e-06 m=1 ng=1 $X=955 $Y=2640 $D=6
M2 10 5 2 2 sg13_lv_pmos w=6.7e-07 l=1.3e-07 as=1.9465e-13 ad=2.9485e-13 ps=1.99071e-06 pd=2.255e-06 m=1 ng=1 $X=1475 $Y=1760 $D=6
M3 9 6 10 2 sg13_lv_pmos w=6.7e-07 l=1.3e-07 as=5.897e-13 ad=6.365e-14 ps=4.51e-06 pd=5.25e-07 m=1 ng=1 $X=1935 $Y=1970 $D=6
M4 10 7 9 2 sg13_lv_pmos w=6.7e-07 l=1.3e-07 as=1.273e-13 ad=2.9485e-13 ps=1.05e-06 pd=2.255e-06 m=1 ng=1 $X=2445 $Y=1970 $D=6
M5 3 9 1 3 sg13_lv_nmos w=4.4e-07 l=1.3e-07 as=1.496e-13 ad=4.361e-13 ps=1.56e-06 pd=3.13333e-06 m=1 ng=1 $X=445 $Y=780 $D=10
M6 11 4 3 3 sg13_lv_nmos w=4.4e-07 l=1.3e-07 as=6.5415e-13 ad=3.66667e-14 ps=4.7e-06 pd=4.6e-07 m=1 ng=1 $X=985 $Y=700 $D=10
M7 9 5 11 3 sg13_lv_nmos w=4.4e-07 l=1.3e-07 as=5.5e-14 ad=8.8e-14 ps=6.9e-07 pd=8.4e-07 m=1 ng=1 $X=1365 $Y=700 $D=10
M8 12 6 9 3 sg13_lv_nmos w=4.4e-07 l=1.3e-07 as=8.8e-14 ad=5.5e-14 ps=8.4e-07 pd=6.9e-07 m=1 ng=1 $X=1895 $Y=700 $D=10
M9 3 7 12 3 sg13_lv_nmos w=4.4e-07 l=1.3e-07 as=5.5e-14 ad=4.361e-13 ps=6.9e-07 pd=3.13333e-06 m=1 ng=1 $X=2275 $Y=700 $D=10
.ENDS
***************************************
.SUBCKT NA2JIX1 1 2 3 4 5
** N=7 EP=5 IP=0 FDC=4
M0 3 4 1 1 sg13_lv_pmos w=1.34e-06 l=1.3e-07 as=5.858e-13 ad=2.546e-13 ps=4.02e-06 pd=1.72e-06 m=1 ng=1 $X=475 $Y=1970 $D=6
M1 1 5 3 1 sg13_lv_pmos w=1.34e-06 l=1.3e-07 as=2.546e-13 ad=7.334e-13 ps=1.72e-06 pd=4.2e-06 m=1 ng=1 $X=985 $Y=1970 $D=6
M2 7 4 2 2 sg13_lv_nmos w=8.8e-07 l=1.3e-07 as=5.909e-13 ad=1.496e-13 ps=3.42e-06 pd=1.22e-06 m=1 ng=1 $X=635 $Y=470 $D=10
M3 3 5 7 2 sg13_lv_nmos w=8.8e-07 l=1.3e-07 as=1.496e-13 ad=2.992e-13 ps=1.22e-06 pd=2.44e-06 m=1 ng=1 $X=1105 $Y=470 $D=10
.ENDS
***************************************
.SUBCKT EO2JIX1 1 2 3 4 5
** N=10 EP=5 IP=0 FDC=10
M0 7 4 1 1 sg13_lv_pmos w=1.1e-06 l=1.3e-07 as=4.106e-13 ad=1.21e-13 ps=3.84e-06 pd=1.32e-06 m=1 ng=1 $X=385 $Y=1970 $D=6
M1 8 5 7 1 sg13_lv_pmos w=1.1e-06 l=1.3e-07 as=1.21e-13 ad=3.74e-13 ps=1.32e-06 pd=2.88e-06 m=1 ng=1 $X=735 $Y=1970 $D=6
M2 1 4 9 1 sg13_lv_pmos w=1.34e-06 l=1.3e-07 as=4.556e-13 ad=2.876e-13 ps=3.36e-06 pd=2.02e-06 m=1 ng=1 $X=1760 $Y=1970 $D=6
M3 9 5 1 1 sg13_lv_pmos w=1.34e-06 l=1.3e-07 as=2.876e-13 ad=2.546e-13 ps=2.02e-06 pd=1.72e-06 m=1 ng=1 $X=2270 $Y=1970 $D=6
M4 2 8 9 1 sg13_lv_pmos w=1.34e-06 l=1.3e-07 as=2.546e-13 ad=4.556e-13 ps=1.72e-06 pd=3.36e-06 m=1 ng=1 $X=2780 $Y=1970 $D=6
M5 8 4 3 3 sg13_lv_nmos w=8.8e-07 l=1.3e-07 as=5.954e-13 ad=1.716e-13 ps=3.42e-06 pd=1.27e-06 m=1 ng=1 $X=720 $Y=470 $D=10
M6 3 5 8 3 sg13_lv_nmos w=8.8e-07 l=1.3e-07 as=1.716e-13 ad=2.046e-13 ps=1.27e-06 pd=1.57e-06 m=1 ng=1 $X=1240 $Y=470 $D=10
M7 10 4 3 3 sg13_lv_nmos w=8.8e-07 l=1.3e-07 as=2.046e-13 ad=7.92e-14 ps=1.57e-06 pd=1.06e-06 m=1 ng=1 $X=1760 $Y=470 $D=10
M8 2 5 10 3 sg13_lv_nmos w=8.8e-07 l=1.3e-07 as=7.92e-14 ad=1.738e-13 ps=1.06e-06 pd=1.275e-06 m=1 ng=1 $X=2070 $Y=470 $D=10
M9 3 8 2 3 sg13_lv_nmos w=8.8e-07 l=1.3e-07 as=1.738e-13 ad=4.538e-13 ps=1.275e-06 pd=3.18e-06 m=1 ng=1 $X=2595 $Y=470 $D=10
.ENDS
***************************************
.SUBCKT ICV_3
** N=4 EP=0 IP=6 FDC=0
.ENDS
***************************************
.SUBCKT INVJIX1 1 2 3 4
** N=5 EP=4 IP=0 FDC=2
M0 3 4 1 1 sg13_lv_pmos w=1.34e-06 l=1.3e-07 as=9.078e-13 ad=4.69e-13 ps=4.42e-06 pd=3.38e-06 m=1 ng=1 $X=675 $Y=1970 $D=6
M1 3 4 2 2 sg13_lv_nmos w=8.8e-07 l=1.3e-07 as=6.516e-13 ad=3.08e-13 ps=3.5e-06 pd=2.46e-06 m=1 ng=1 $X=675 $Y=470 $D=10
.ENDS
***************************************
.SUBCKT DECAP10JI 1 2
** N=5 EP=2 IP=0 FDC=6
M0 1 5 1 1 sg13_lv_pmos w=1.34e-06 l=1.24e-06 as=3.8e-13 ad=2.537e-13 ps=3.78e-06 pd=1.975e-06 m=1 ng=1 $X=355 $Y=1970 $D=6
M1 1 5 1 1 sg13_lv_pmos w=1.34e-06 l=1.24e-06 as=2.537e-13 ad=2.44e-13 ps=1.975e-06 pd=1.97e-06 m=1 ng=1 $X=1930 $Y=1970 $D=6
M2 4 5 1 1 sg13_lv_pmos w=1.18e-06 l=1.3e-07 as=2.44e-13 ad=5.487e-13 ps=1.97e-06 pd=3.29e-06 m=1 ng=1 $X=3500 $Y=2130 $D=6
M3 2 4 5 2 sg13_lv_nmos w=7.6e-07 l=1.3e-07 as=3.534e-13 ad=1.695e-13 ps=2.45e-06 pd=1.51e-06 m=1 ng=1 $X=570 $Y=470 $D=10
M4 2 4 2 2 sg13_lv_nmos w=8.8e-07 l=1.24e-06 as=1.695e-13 ad=1.7665e-13 ps=1.51e-06 pd=1.515e-06 m=1 ng=1 $X=1030 $Y=470 $D=10
M5 2 4 2 2 sg13_lv_nmos w=8.8e-07 l=1.24e-06 as=1.7665e-13 ad=2.65e-13 ps=1.515e-06 pd=2.86e-06 m=1 ng=1 $X=2605 $Y=470 $D=10
.ENDS
***************************************
.SUBCKT NA2JIX0 1 2 3 4 5
** N=7 EP=5 IP=0 FDC=4
M0 1 4 2 2 sg13_lv_pmos w=6.7e-07 l=1.3e-07 as=8.584e-13 ad=1.273e-13 ps=4.26e-06 pd=1.05e-06 m=1 ng=1 $X=475 $Y=1970 $D=6
M1 2 5 1 2 sg13_lv_pmos w=6.7e-07 l=1.3e-07 as=1.273e-13 ad=8.584e-13 ps=1.05e-06 pd=4.26e-06 m=1 ng=1 $X=985 $Y=1970 $D=6
M2 7 4 3 3 sg13_lv_nmos w=4.4e-07 l=1.3e-07 as=1.03087e-12 ad=7.48e-14 ps=5.53e-06 pd=7.8e-07 m=1 ng=1 $X=635 $Y=910 $D=10
M3 1 5 7 3 sg13_lv_nmos w=4.4e-07 l=1.3e-07 as=7.48e-14 ad=1.496e-13 ps=7.8e-07 pd=1.56e-06 m=1 ng=1 $X=1105 $Y=910 $D=10
.ENDS
***************************************
.SUBCKT ICV_4 1 2 3 4 5
*.CALIBRE ICV_CELL 9
** N=6 EP=5 IP=9 FDC=4
X1 5 2 1 3 4 NA2JIX0 $T=840 0 0 0 $X=540 $Y=-260
.ENDS
***************************************
.SUBCKT ICV_5
** N=4 EP=0 IP=6 FDC=0
.ENDS
***************************************
.SUBCKT EO2JIX0 1 2 3 4 5
** N=10 EP=5 IP=0 FDC=10
M0 7 4 1 1 sg13_lv_pmos w=6.7e-07 l=1.3e-07 as=9.52137e-13 ad=4.91333e-14 ps=6.065e-06 pd=5.93333e-07 m=1 ng=1 $X=385 $Y=1970 $D=6
M1 8 5 7 1 sg13_lv_pmos w=6.7e-07 l=1.3e-07 as=7.37e-14 ad=2.278e-13 ps=8.9e-07 pd=2.02e-06 m=1 ng=1 $X=735 $Y=1970 $D=6
M2 1 4 9 1 sg13_lv_pmos w=6.7e-07 l=1.3e-07 as=2.278e-13 ad=6.34758e-13 ps=2.02e-06 pd=4.04333e-06 m=1 ng=1 $X=1760 $Y=2210 $D=6
M3 9 5 1 1 sg13_lv_pmos w=6.7e-07 l=1.3e-07 as=6.34758e-13 ad=1.273e-13 ps=4.04333e-06 pd=1.05e-06 m=1 ng=1 $X=2270 $Y=2210 $D=6
M4 2 8 9 1 sg13_lv_pmos w=6.7e-07 l=1.3e-07 as=1.273e-13 ad=2.278e-13 ps=1.05e-06 pd=2.02e-06 m=1 ng=1 $X=2780 $Y=2210 $D=6
M5 8 4 3 3 sg13_lv_nmos w=4.4e-07 l=1.3e-07 as=1.06605e-12 ad=4.29e-14 ps=5.915e-06 pd=4.15e-07 m=1 ng=1 $X=720 $Y=880 $D=10
M6 3 5 8 3 sg13_lv_nmos w=4.4e-07 l=1.3e-07 as=8.58e-14 ad=5.33025e-13 ps=8.3e-07 pd=2.9575e-06 m=1 ng=1 $X=1240 $Y=880 $D=10
M7 10 4 3 3 sg13_lv_nmos w=4.4e-07 l=1.3e-07 as=1.06605e-12 ad=1.98e-14 ps=5.915e-06 pd=3.1e-07 m=1 ng=1 $X=1760 $Y=880 $D=10
M8 2 5 10 3 sg13_lv_nmos w=4.4e-07 l=1.3e-07 as=3.96e-14 ad=8.69e-14 ps=6.2e-07 pd=8.35e-07 m=1 ng=1 $X=2070 $Y=880 $D=10
M9 3 8 2 3 sg13_lv_nmos w=4.4e-07 l=1.3e-07 as=8.69e-14 ad=5.33025e-13 ps=8.35e-07 pd=2.9575e-06 m=1 ng=1 $X=2595 $Y=880 $D=10
.ENDS
***************************************
.SUBCKT ICV_6 1 2 3 4 5 6 7
*.CALIBRE ICV_CELL 9
** N=8 EP=7 IP=11 FDC=10
X1 3 2 1 4 5 6 7 AO22JIX0 $T=420 0 0 0 $X=120 $Y=-260
.ENDS
***************************************
.SUBCKT viagen34_CDNS_754739516588
** N=3 EP=0 IP=0 FDC=0
.ENDS
***************************************
.SUBCKT ICV_7
** N=3 EP=0 IP=6 FDC=0
.ENDS
***************************************
.SUBCKT ICV_8
** N=3 EP=0 IP=6 FDC=0
.ENDS
***************************************
.SUBCKT NA2I1JIX0 1 2 3 4 5
** N=8 EP=5 IP=0 FDC=6
M0 2 4 7 2 sg13_lv_pmos w=6.7e-07 l=1.3e-07 as=2.3115e-13 ad=6.3795e-13 ps=2.03e-06 pd=3.15e-06 m=1 ng=1 $X=450 $Y=1970 $D=6
M1 1 5 2 2 sg13_lv_pmos w=6.7e-07 l=1.3e-07 as=9.56925e-13 ad=9.715e-14 ps=4.725e-06 pd=7.36667e-07 m=1 ng=1 $X=1050 $Y=1970 $D=6
M2 2 7 1 2 sg13_lv_pmos w=6.7e-07 l=1.3e-07 as=1.45725e-13 ad=6.3795e-13 ps=1.105e-06 pd=3.15e-06 m=1 ng=1 $X=1615 $Y=1970 $D=6
M3 3 4 7 3 sg13_lv_nmos w=4.4e-07 l=1.3e-07 as=1.518e-13 ad=5.765e-13 ps=1.57e-06 pd=3.21e-06 m=1 ng=1 $X=450 $Y=910 $D=10
M4 8 5 3 3 sg13_lv_nmos w=4.4e-07 l=1.3e-07 as=5.765e-13 ad=5.5e-14 ps=3.21e-06 pd=6.9e-07 m=1 ng=1 $X=1050 $Y=910 $D=10
M5 1 7 8 3 sg13_lv_nmos w=4.4e-07 l=1.3e-07 as=5.5e-14 ad=1.914e-13 ps=6.9e-07 pd=1.75e-06 m=1 ng=1 $X=1430 $Y=910 $D=10
.ENDS
***************************************
.SUBCKT INVJIX0 1 2 3 4
** N=5 EP=4 IP=0 FDC=2
M0 2 4 1 1 sg13_lv_pmos w=6.7e-07 l=1.3e-07 as=8.475e-13 ad=2.345e-13 ps=4.42e-06 pd=2.04e-06 m=1 ng=1 $X=675 $Y=1970 $D=6
M1 2 4 3 3 sg13_lv_nmos w=4.4e-07 l=1.3e-07 as=7.803e-13 ad=1.54e-13 ps=4.6e-06 pd=1.58e-06 m=1 ng=1 $X=675 $Y=910 $D=10
.ENDS
***************************************
.SUBCKT ICV_9
** N=4 EP=0 IP=6 FDC=0
.ENDS
***************************************
.SUBCKT OR2JIX0 1 2 3 4 5
** N=8 EP=5 IP=0 FDC=6
M0 8 4 7 1 sg13_lv_pmos w=6.7e-07 l=1.3e-07 as=2.278e-13 ad=8.375e-14 ps=2.02e-06 pd=9.2e-07 m=1 ng=1 $X=445 $Y=1970 $D=6
M1 1 5 8 1 sg13_lv_pmos w=6.7e-07 l=1.3e-07 as=8.375e-14 ad=9.032e-13 ps=9.2e-07 pd=3.67e-06 m=1 ng=1 $X=825 $Y=1970 $D=6
M2 2 7 1 1 sg13_lv_pmos w=6.7e-07 l=1.3e-07 as=9.032e-13 ad=2.278e-13 ps=3.67e-06 pd=2.02e-06 m=1 ng=1 $X=1525 $Y=1970 $D=6
M3 7 4 3 3 sg13_lv_nmos w=4.4e-07 l=1.3e-07 as=6.3885e-13 ad=5.57333e-14 ps=3.95e-06 pd=5.46667e-07 m=1 ng=1 $X=445 $Y=860 $D=10
M4 3 5 7 3 sg13_lv_nmos w=4.4e-07 l=1.3e-07 as=8.36e-14 ad=4.259e-13 ps=8.2e-07 pd=2.63333e-06 m=1 ng=1 $X=955 $Y=860 $D=10
M5 2 7 3 3 sg13_lv_nmos w=4.4e-07 l=1.3e-07 as=4.259e-13 ad=1.496e-13 ps=2.63333e-06 pd=1.56e-06 m=1 ng=1 $X=1525 $Y=860 $D=10
.ENDS
***************************************
.SUBCKT FEED10JI
** N=4 EP=0 IP=0 FDC=0
.ENDS
***************************************
.SUBCKT SDFRRQJIX1 1 2 3 4 5 6 7 8
** N=30 EP=8 IP=0 FDC=38
M0 1 4 10 1 sg13_lv_pmos w=5.5e-07 l=1.3e-07 as=1.87e-13 ad=2.77575e-13 ps=1.78e-06 pd=1.66e-06 m=1 ng=1 $X=445 $Y=2760 $D=6
M1 11 10 1 1 sg13_lv_pmos w=6.4e-07 l=1.3e-07 as=2.77575e-13 ad=5.76e-14 ps=1.66e-06 pd=8.2e-07 m=1 ng=1 $X=1355 $Y=2430 $D=6
M2 12 5 11 1 sg13_lv_pmos w=6.4e-07 l=1.3e-07 as=5.76e-14 ad=1.232e-13 ps=8.2e-07 pd=1.025e-06 m=1 ng=1 $X=1665 $Y=2430 $D=6
M3 13 6 12 1 sg13_lv_pmos w=6.4e-07 l=1.3e-07 as=1.232e-13 ad=5.76e-14 ps=1.025e-06 pd=8.2e-07 m=1 ng=1 $X=2180 $Y=2430 $D=6
M4 1 4 13 1 sg13_lv_pmos w=6.4e-07 l=1.3e-07 as=5.76e-14 ad=1.612e-13 ps=8.2e-07 pd=1.54e-06 m=1 ng=1 $X=2490 $Y=2430 $D=6
M5 14 15 1 1 sg13_lv_pmos w=7.5e-07 l=1.3e-07 as=1.612e-13 ad=2.55e-13 ps=1.54e-06 pd=2.18e-06 m=1 ng=1 $X=2980 $Y=2560 $D=6
M6 1 8 15 1 sg13_lv_pmos w=3e-07 l=1.3e-07 as=1.02e-13 ad=3.218e-13 ps=1.28e-06 pd=2.25e-06 m=1 ng=1 $X=3720 $Y=2050 $D=6
M7 16 14 1 1 sg13_lv_pmos w=3e-07 l=1.3e-07 as=3.218e-13 ad=2.7e-14 ps=2.25e-06 pd=4.8e-07 m=1 ng=1 $X=4250 $Y=2415 $D=6
M8 15 18 16 1 sg13_lv_pmos w=3e-07 l=1.3e-07 as=2.7e-14 ad=9.7825e-14 ps=4.8e-07 pd=1.035e-06 m=1 ng=1 $X=4560 $Y=2415 $D=6
M9 12 17 15 1 sg13_lv_pmos w=6.55e-07 l=1.3e-07 as=9.7825e-14 ad=2.7365e-13 ps=1.035e-06 pd=2.59e-06 m=1 ng=1 $X=5070 $Y=2415 $D=6
M10 1 18 17 1 sg13_lv_pmos w=5.4e-07 l=1.3e-07 as=1.8015e-13 ad=3.02167e-13 ps=1.77e-06 pd=2.07e-06 m=1 ng=1 $X=5980 $Y=2065 $D=6
M11 18 7 1 1 sg13_lv_pmos w=5.4e-07 l=1.3e-07 as=9.065e-13 ad=5.45667e-14 ps=6.21e-06 pd=5.93333e-07 m=1 ng=1 $X=6470 $Y=2065 $D=6
M12 19 14 1 1 sg13_lv_pmos w=6.1e-07 l=1.3e-07 as=3.02167e-13 ad=5.49e-14 ps=2.07e-06 pd=7.9e-07 m=1 ng=1 $X=7435 $Y=2455 $D=6
M13 20 18 19 1 sg13_lv_pmos w=6.1e-07 l=1.3e-07 as=5.49e-14 ad=1.035e-13 ps=7.9e-07 pd=9.9e-07 m=1 ng=1 $X=7745 $Y=2455 $D=6
M14 21 17 20 1 sg13_lv_pmos w=3e-07 l=1.3e-07 as=1.035e-13 ad=2.7e-14 ps=9.9e-07 pd=4.8e-07 m=1 ng=1 $X=8255 $Y=2455 $D=6
M15 1 22 21 1 sg13_lv_pmos w=3e-07 l=1.3e-07 as=2.7e-14 ad=3.77017e-13 ps=4.8e-07 pd=2.31333e-06 m=1 ng=1 $X=8565 $Y=2455 $D=6
M16 20 8 1 1 sg13_lv_pmos w=3e-07 l=1.3e-07 as=1.13105e-12 ad=3.4e-14 ps=6.94e-06 pd=4.26667e-07 m=1 ng=1 $X=9055 $Y=1970 $D=6
M17 22 20 1 1 sg13_lv_pmos w=7.3e-07 l=1.3e-07 as=3.77017e-13 ad=2.482e-13 ps=2.31333e-06 pd=2.14e-06 m=1 ng=1 $X=9365 $Y=2580 $D=6
M18 3 20 1 1 sg13_lv_pmos w=1.34e-06 l=1.3e-07 as=4.71e-13 ad=4.556e-13 ps=3.88e-06 pd=3.36e-06 m=1 ng=1 $X=10345 $Y=1970 $D=6
M19 10 4 2 2 sg13_lv_nmos w=3.6e-07 l=1.3e-07 as=2.985e-13 ad=1.224e-13 ps=3.16e-06 pd=1.4e-06 m=1 ng=1 $X=355 $Y=990 $D=10
M20 24 10 23 2 sg13_lv_nmos w=3.85e-07 l=1.3e-07 as=1.63325e-13 ad=3.465e-14 ps=1.75e-06 pd=5.65e-07 m=1 ng=1 $X=1310 $Y=470 $D=10
M21 25 4 23 2 sg13_lv_nmos w=3.85e-07 l=1.3e-07 as=1.63325e-13 ad=3.465e-14 ps=1.75e-06 pd=5.65e-07 m=1 ng=1 $X=1380 $Y=1395 $D=10
M22 26 6 24 2 sg13_lv_nmos w=3.85e-07 l=1.3e-07 as=3.465e-14 ad=1.63325e-13 ps=5.65e-07 pd=1.75e-06 m=1 ng=1 $X=1620 $Y=470 $D=10
M23 26 5 25 2 sg13_lv_nmos w=3.85e-07 l=1.3e-07 as=3.465e-14 ad=1.63325e-13 ps=5.65e-07 pd=1.75e-06 m=1 ng=1 $X=1690 $Y=1395 $D=10
M24 2 15 14 2 sg13_lv_nmos w=6e-07 l=1.3e-07 as=2.82e-13 ad=1.565e-13 ps=2.3e-06 pd=1.46e-06 m=1 ng=1 $X=2830 $Y=670 $D=10
M25 23 8 2 2 sg13_lv_nmos w=8e-07 l=1.3e-07 as=1.565e-13 ad=1.27e-13 ps=1.46e-06 pd=1.18e-06 m=1 ng=1 $X=3320 $Y=470 $D=10
M26 27 14 23 2 sg13_lv_nmos w=3e-07 l=1.3e-07 as=1.27e-13 ad=2.7e-14 ps=1.18e-06 pd=4.8e-07 m=1 ng=1 $X=3830 $Y=855 $D=10
M27 15 17 27 2 sg13_lv_nmos w=3e-07 l=1.3e-07 as=2.7e-14 ad=1.00562e-13 ps=4.8e-07 pd=1.015e-06 m=1 ng=1 $X=4140 $Y=855 $D=10
M28 26 18 15 2 sg13_lv_nmos w=4e-07 l=1.3e-07 as=1.00562e-13 ad=1.25e-13 ps=1.015e-06 pd=1.48e-06 m=1 ng=1 $X=4710 $Y=1030 $D=10
M29 2 18 17 2 sg13_lv_nmos w=3.2e-07 l=1.3e-07 as=1.088e-13 ad=1.418e-13 ps=1.32e-06 pd=1.445e-06 m=1 ng=1 $X=5730 $Y=990 $D=10
M30 18 7 2 2 sg13_lv_nmos w=3.2e-07 l=1.3e-07 as=1.418e-13 ad=1.344e-13 ps=1.445e-06 pd=1.62e-06 m=1 ng=1 $X=6190 $Y=990 $D=10
M31 29 14 28 2 sg13_lv_nmos w=3.6e-07 l=1.3e-07 as=1.9215e-13 ad=3.24e-14 ps=2.09e-06 pd=5.4e-07 m=1 ng=1 $X=7135 $Y=710 $D=10
M32 20 17 29 2 sg13_lv_nmos w=3.6e-07 l=1.3e-07 as=3.24e-14 ad=6.63e-14 ps=5.4e-07 pd=7.4e-07 m=1 ng=1 $X=7445 $Y=710 $D=10
M33 30 18 20 2 sg13_lv_nmos w=3e-07 l=1.3e-07 as=6.63e-14 ad=2.7e-14 ps=7.4e-07 pd=4.8e-07 m=1 ng=1 $X=7955 $Y=770 $D=10
M34 28 22 30 2 sg13_lv_nmos w=3e-07 l=1.3e-07 as=2.7e-14 ad=1.305e-13 ps=4.8e-07 pd=1.08e-06 m=1 ng=1 $X=8265 $Y=770 $D=10
M35 2 8 28 2 sg13_lv_nmos w=6e-07 l=1.3e-07 as=1.305e-13 ad=1.335e-13 ps=1.08e-06 pd=1.25e-06 m=1 ng=1 $X=8875 $Y=470 $D=10
M36 22 20 2 2 sg13_lv_nmos w=6e-07 l=1.3e-07 as=1.335e-13 ad=2.04e-13 ps=1.25e-06 pd=1.88e-06 m=1 ng=1 $X=9355 $Y=470 $D=10
M37 3 20 2 2 sg13_lv_nmos w=8.8e-07 l=1.3e-07 as=3.448e-13 ad=2.992e-13 ps=2.98e-06 pd=2.44e-06 m=1 ng=1 $X=10345 $Y=470 $D=10
.ENDS
***************************************
.SUBCKT SDFRRSJIX1 1 2 3 4 5 6 7 8 9
** N=34 EP=9 IP=0 FDC=44
M0 1 5 11 1 sg13_lv_pmos w=5.5e-07 l=1.3e-07 as=1.87e-13 ad=2.28425e-13 ps=1.78e-06 pd=1.475e-06 m=1 ng=1 $X=445 $Y=2575 $D=6
M1 12 11 1 1 sg13_lv_pmos w=6.4e-07 l=1.3e-07 as=2.28425e-13 ad=5.76e-14 ps=1.475e-06 pd=8.2e-07 m=1 ng=1 $X=1355 $Y=2430 $D=6
M2 13 6 12 1 sg13_lv_pmos w=6.4e-07 l=1.3e-07 as=5.76e-14 ad=1.232e-13 ps=8.2e-07 pd=1.025e-06 m=1 ng=1 $X=1665 $Y=2430 $D=6
M3 14 7 13 1 sg13_lv_pmos w=6.4e-07 l=1.3e-07 as=1.232e-13 ad=5.76e-14 ps=1.025e-06 pd=8.2e-07 m=1 ng=1 $X=2180 $Y=2430 $D=6
M4 1 5 14 1 sg13_lv_pmos w=6.4e-07 l=1.3e-07 as=5.76e-14 ad=1.8455e-13 ps=8.2e-07 pd=1.88e-06 m=1 ng=1 $X=2490 $Y=2430 $D=6
M5 15 16 1 1 sg13_lv_pmos w=6.4e-07 l=1.3e-07 as=1.8455e-13 ad=1.216e-13 ps=1.88e-06 pd=1.02e-06 m=1 ng=1 $X=2910 $Y=2430 $D=6
M6 1 34 15 1 sg13_lv_pmos w=6.4e-07 l=1.3e-07 as=1.216e-13 ad=2.27567e-13 ps=1.02e-06 pd=1.62333e-06 m=1 ng=1 $X=3420 $Y=2430 $D=6
M7 16 9 1 1 sg13_lv_pmos w=3e-07 l=1.3e-07 as=6.827e-13 ad=3.4e-14 ps=4.87e-06 pd=4.26667e-07 m=1 ng=1 $X=3850 $Y=2050 $D=6
M8 17 15 1 1 sg13_lv_pmos w=3e-07 l=1.3e-07 as=2.27567e-13 ad=2.7e-14 ps=1.62333e-06 pd=4.8e-07 m=1 ng=1 $X=4735 $Y=2450 $D=6
M9 16 19 17 1 sg13_lv_pmos w=3e-07 l=1.3e-07 as=2.7e-14 ad=9.84e-14 ps=4.8e-07 pd=1.04e-06 m=1 ng=1 $X=5045 $Y=2450 $D=6
M10 13 18 16 1 sg13_lv_pmos w=6.6e-07 l=1.3e-07 as=9.84e-14 ad=2.461e-13 ps=1.04e-06 pd=2.6e-06 m=1 ng=1 $X=5555 $Y=2090 $D=6
M11 1 19 18 1 sg13_lv_pmos w=5.4e-07 l=1.3e-07 as=1.572e-13 ad=1.931e-13 ps=1.76e-06 pd=1.70667e-06 m=1 ng=1 $X=6465 $Y=1930 $D=6
M12 19 8 1 1 sg13_lv_pmos w=5.4e-07 l=1.3e-07 as=5.793e-13 ad=5.25625e-14 ps=5.12e-06 pd=5.79832e-07 m=1 ng=1 $X=6885 $Y=1930 $D=6
M13 20 15 1 1 sg13_lv_pmos w=6.1e-07 l=1.3e-07 as=1.931e-13 ad=5.49e-14 ps=1.70667e-06 pd=7.9e-07 m=1 ng=1 $X=7685 $Y=2420 $D=6
M14 21 19 20 1 sg13_lv_pmos w=6.1e-07 l=1.3e-07 as=5.49e-14 ad=9.42e-14 ps=7.9e-07 pd=9.9e-07 m=1 ng=1 $X=7995 $Y=2420 $D=6
M15 22 18 21 1 sg13_lv_pmos w=3e-07 l=1.3e-07 as=9.42e-14 ad=2.7e-14 ps=9.9e-07 pd=4.8e-07 m=1 ng=1 $X=8505 $Y=2420 $D=6
M16 1 23 22 1 sg13_lv_pmos w=3e-07 l=1.3e-07 as=2.7e-14 ad=2.19983e-13 ps=4.8e-07 pd=1.50667e-06 m=1 ng=1 $X=8815 $Y=2420 $D=6
M17 21 9 1 1 sg13_lv_pmos w=4.45e-07 l=1.3e-07 as=2.19983e-13 ad=1.513e-13 ps=1.50667e-06 pd=1.57e-06 m=1 ng=1 $X=9255 $Y=1970 $D=6
M18 23 34 1 1 sg13_lv_pmos w=6.4e-07 l=1.3e-07 as=2.19983e-13 ad=1.216e-13 ps=1.50667e-06 pd=1.02e-06 m=1 ng=1 $X=9795 $Y=2670 $D=6
M19 1 21 23 1 sg13_lv_pmos w=6.4e-07 l=1.3e-07 as=1.216e-13 ad=1.952e-13 ps=1.02e-06 pd=2.34e-06 m=1 ng=1 $X=10305 $Y=2670 $D=6
M20 1 21 2 1 sg13_lv_pmos w=1.34e-06 l=1.3e-07 as=3.621e-13 ad=2.824e-13 ps=3.36e-06 pd=2.01e-06 m=1 ng=1 $X=11105 $Y=1970 $D=6
M21 4 23 1 1 sg13_lv_pmos w=1.34e-06 l=1.3e-07 as=2.824e-13 ad=4.556e-13 ps=2.01e-06 pd=3.36e-06 m=1 ng=1 $X=11605 $Y=1970 $D=6
M22 11 5 3 3 sg13_lv_nmos w=3.6e-07 l=1.3e-07 as=2.985e-13 ad=1.224e-13 ps=3.16e-06 pd=1.4e-06 m=1 ng=1 $X=355 $Y=990 $D=10
M23 25 11 24 3 sg13_lv_nmos w=3.85e-07 l=1.3e-07 as=1.5755e-13 ad=3.465e-14 ps=1.72e-06 pd=5.65e-07 m=1 ng=1 $X=1280 $Y=470 $D=10
M24 26 5 24 3 sg13_lv_nmos w=3.85e-07 l=1.3e-07 as=1.5755e-13 ad=3.465e-14 ps=1.72e-06 pd=5.65e-07 m=1 ng=1 $X=1380 $Y=1395 $D=10
M25 27 7 25 3 sg13_lv_nmos w=3.85e-07 l=1.3e-07 as=3.465e-14 ad=1.5755e-13 ps=5.65e-07 pd=1.72e-06 m=1 ng=1 $X=1590 $Y=470 $D=10
M26 27 6 26 3 sg13_lv_nmos w=3.85e-07 l=1.3e-07 as=3.465e-14 ad=1.5755e-13 ps=5.65e-07 pd=1.72e-06 m=1 ng=1 $X=1690 $Y=1395 $D=10
M27 28 16 15 3 sg13_lv_nmos w=8e-07 l=1.3e-07 as=3.41e-13 ad=7.2e-14 ps=2.64e-06 pd=9.8e-07 m=1 ng=1 $X=2770 $Y=470 $D=10
M28 3 34 28 3 sg13_lv_nmos w=8e-07 l=1.3e-07 as=7.2e-14 ad=1.355e-13 ps=9.8e-07 pd=1.4e-06 m=1 ng=1 $X=3080 $Y=470 $D=10
M29 24 9 3 3 sg13_lv_nmos w=6e-07 l=1.3e-07 as=1.355e-13 ad=9.21e-14 ps=1.4e-06 pd=9.8e-07 m=1 ng=1 $X=3510 $Y=470 $D=10
M30 29 15 24 3 sg13_lv_nmos w=3e-07 l=1.3e-07 as=9.21e-14 ad=2.7e-14 ps=9.8e-07 pd=4.8e-07 m=1 ng=1 $X=4020 $Y=755 $D=10
M31 16 18 29 3 sg13_lv_nmos w=3e-07 l=1.3e-07 as=2.7e-14 ad=1.15625e-13 ps=4.8e-07 pd=1.085e-06 m=1 ng=1 $X=4330 $Y=755 $D=10
M32 27 19 16 3 sg13_lv_nmos w=4e-07 l=1.3e-07 as=1.15625e-13 ad=1.36e-13 ps=1.085e-06 pd=1.48e-06 m=1 ng=1 $X=4870 $Y=1030 $D=10
M33 3 19 18 3 sg13_lv_nmos w=3.2e-07 l=1.3e-07 as=1.088e-13 ad=1.592e-13 ps=1.32e-06 pd=1.63e-06 m=1 ng=1 $X=5950 $Y=970 $D=10
M34 19 8 3 3 sg13_lv_nmos w=3.2e-07 l=1.3e-07 as=1.592e-13 ad=1.088e-13 ps=1.63e-06 pd=1.32e-06 m=1 ng=1 $X=6380 $Y=780 $D=10
M35 31 15 30 3 sg13_lv_nmos w=3.6e-07 l=1.3e-07 as=2.067e-13 ad=3.24e-14 ps=1.95e-06 pd=5.4e-07 m=1 ng=1 $X=7650 $Y=710 $D=10
M36 21 18 31 3 sg13_lv_nmos w=3.6e-07 l=1.3e-07 as=3.24e-14 ad=6.39e-14 ps=5.4e-07 pd=7.4e-07 m=1 ng=1 $X=7960 $Y=710 $D=10
M37 32 19 21 3 sg13_lv_nmos w=3e-07 l=1.3e-07 as=6.39e-14 ad=2.7e-14 ps=7.4e-07 pd=4.8e-07 m=1 ng=1 $X=8470 $Y=770 $D=10
M38 30 23 32 3 sg13_lv_nmos w=3e-07 l=1.3e-07 as=2.7e-14 ad=1.125e-13 ps=4.8e-07 pd=1.01e-06 m=1 ng=1 $X=8780 $Y=770 $D=10
M39 3 9 30 3 sg13_lv_nmos w=6e-07 l=1.3e-07 as=1.125e-13 ad=1.7e-13 ps=1.01e-06 pd=1.46e-06 m=1 ng=1 $X=9320 $Y=470 $D=10
M40 33 34 3 3 sg13_lv_nmos w=8e-07 l=1.3e-07 as=1.7e-13 ad=7.2e-14 ps=1.46e-06 pd=9.8e-07 m=1 ng=1 $X=9810 $Y=470 $D=10
M41 23 21 33 3 sg13_lv_nmos w=8e-07 l=1.3e-07 as=7.2e-14 ad=2.72e-13 ps=9.8e-07 pd=2.28e-06 m=1 ng=1 $X=10120 $Y=470 $D=10
M42 3 21 2 3 sg13_lv_nmos w=8.8e-07 l=1.3e-07 as=2.992e-13 ad=1.737e-13 ps=2.44e-06 pd=1.51e-06 m=1 ng=1 $X=11145 $Y=470 $D=10
M43 4 23 3 3 sg13_lv_nmos w=8.8e-07 l=1.3e-07 as=1.737e-13 ad=2.992e-13 ps=1.51e-06 pd=2.44e-06 m=1 ng=1 $X=11605 $Y=470 $D=10
.ENDS
***************************************
.SUBCKT ICV_10 1 2 3 4 5 6 7
*.CALIBRE ICV_CELL 9
** N=8 EP=7 IP=11 FDC=10
X1 3 2 1 4 5 6 7 AO22JIX0 $T=840 0 0 0 $X=540 $Y=-260
.ENDS
***************************************
.SUBCKT ON21JIX1 1 2 3 4 5 6
** N=9 EP=6 IP=0 FDC=6
M0 2 4 1 2 sg13_lv_pmos w=1.34e-06 l=1.3e-07 as=4.556e-13 ad=4.546e-13 ps=3.36e-06 pd=2.22e-06 m=1 ng=1 $X=445 $Y=1970 $D=6
M1 8 5 2 2 sg13_lv_pmos w=1.34e-06 l=1.3e-07 as=4.546e-13 ad=1.608e-13 ps=2.22e-06 pd=1.58e-06 m=1 ng=1 $X=1155 $Y=1970 $D=6
M2 1 6 8 2 sg13_lv_pmos w=1.34e-06 l=1.3e-07 as=1.608e-13 ad=4.556e-13 ps=1.58e-06 pd=3.36e-06 m=1 ng=1 $X=1525 $Y=1970 $D=6
M3 9 4 1 3 sg13_lv_nmos w=8.8e-07 l=1.3e-07 as=2.992e-13 ad=1.672e-13 ps=2.44e-06 pd=1.26e-06 m=1 ng=1 $X=445 $Y=470 $D=10
M4 3 5 9 3 sg13_lv_nmos w=8.8e-07 l=1.3e-07 as=1.672e-13 ad=2.386e-13 ps=1.26e-06 pd=1.62e-06 m=1 ng=1 $X=955 $Y=470 $D=10
M5 9 6 3 3 sg13_lv_nmos w=8.8e-07 l=1.3e-07 as=2.386e-13 ad=2.992e-13 ps=1.62e-06 pd=2.44e-06 m=1 ng=1 $X=1525 $Y=470 $D=10
.ENDS
***************************************
.SUBCKT EN2JIX0 1 2 3 4 5
** N=10 EP=5 IP=0 FDC=10
M0 7 5 3 3 sg13_lv_pmos w=6.7e-07 l=1.3e-07 as=1.7198e-12 ad=6.61625e-14 ps=7.02e-06 pd=5.325e-07 m=1 ng=1 $X=695 $Y=1970 $D=6
M1 3 4 7 3 sg13_lv_pmos w=6.7e-07 l=1.3e-07 as=1.32325e-13 ad=8.599e-13 ps=1.065e-06 pd=3.51e-06 m=1 ng=1 $X=1220 $Y=1970 $D=6
M2 8 4 3 3 sg13_lv_pmos w=6.7e-07 l=1.3e-07 as=1.7198e-12 ad=3.015e-14 ps=7.02e-06 pd=4.25e-07 m=1 ng=1 $X=1750 $Y=1970 $D=6
M3 2 5 8 3 sg13_lv_pmos w=6.7e-07 l=1.3e-07 as=6.03e-14 ad=1.65825e-13 ps=8.5e-07 pd=1.165e-06 m=1 ng=1 $X=2060 $Y=1970 $D=6
M4 3 7 2 3 sg13_lv_pmos w=6.7e-07 l=1.3e-07 as=1.65825e-13 ad=8.599e-13 ps=1.165e-06 pd=3.51e-06 m=1 ng=1 $X=2685 $Y=1970 $D=6
M5 9 5 1 1 sg13_lv_nmos w=4.4e-07 l=1.3e-07 as=5.9895e-13 ad=3.96e-14 ps=4.47e-06 pd=6.2e-07 m=1 ng=1 $X=420 $Y=800 $D=10
M6 7 4 9 1 sg13_lv_nmos w=4.4e-07 l=1.3e-07 as=3.96e-14 ad=1.496e-13 ps=6.2e-07 pd=1.56e-06 m=1 ng=1 $X=730 $Y=800 $D=10
M7 1 4 10 1 sg13_lv_nmos w=4.4e-07 l=1.3e-07 as=1.496e-13 ad=1.1705e-13 ps=1.56e-06 pd=1.12e-06 m=1 ng=1 $X=1750 $Y=480 $D=10
M8 10 5 1 1 sg13_lv_nmos w=4.4e-07 l=1.3e-07 as=1.1705e-13 ad=8.8e-14 ps=1.12e-06 pd=8.4e-07 m=1 ng=1 $X=2250 $Y=480 $D=10
M9 2 7 10 1 sg13_lv_nmos w=4.4e-07 l=1.3e-07 as=8.8e-14 ad=1.518e-13 ps=8.4e-07 pd=1.57e-06 m=1 ng=1 $X=2780 $Y=480 $D=10
.ENDS
***************************************
.SUBCKT ICV_11
** N=3 EP=0 IP=6 FDC=0
.ENDS
***************************************
.SUBCKT NO2JIX1 1 2 3 4 5
** N=7 EP=5 IP=0 FDC=4
M0 7 4 1 1 sg13_lv_pmos w=1.34e-06 l=1.3e-07 as=7.416e-13 ad=1.206e-13 ps=4.21e-06 pd=1.52e-06 m=1 ng=1 $X=570 $Y=1970 $D=6
M1 2 5 7 1 sg13_lv_pmos w=1.34e-06 l=1.3e-07 as=1.206e-13 ad=4.556e-13 ps=1.52e-06 pd=3.36e-06 m=1 ng=1 $X=880 $Y=1970 $D=6
M2 2 4 3 3 sg13_lv_nmos w=8.8e-07 l=1.3e-07 as=5.277e-13 ad=1.672e-13 ps=3.29e-06 pd=1.26e-06 m=1 ng=1 $X=570 $Y=470 $D=10
M3 3 5 2 3 sg13_lv_nmos w=8.8e-07 l=1.3e-07 as=1.672e-13 ad=4.097e-13 ps=1.26e-06 pd=3.09e-06 m=1 ng=1 $X=1080 $Y=470 $D=10
.ENDS
***************************************
.SUBCKT ICV_12 1 2 3 4 5
*.CALIBRE ICV_CELL 9
** N=6 EP=5 IP=9 FDC=4
X1 2 1 5 3 4 NA2JIX1 $T=420 0 0 0 $X=120 $Y=-260
.ENDS
***************************************
.SUBCKT ICV_13
** N=4 EP=0 IP=6 FDC=0
.ENDS
***************************************
.SUBCKT NO2I1JIX0 1 2 3 4 5
** N=8 EP=5 IP=0 FDC=6
M0 1 4 7 1 sg13_lv_pmos w=6.7e-07 l=1.3e-07 as=2.3115e-13 ad=8.2315e-13 ps=2.03e-06 pd=3.67e-06 m=1 ng=1 $X=450 $Y=1970 $D=6
M1 8 5 1 1 sg13_lv_pmos w=6.7e-07 l=1.3e-07 as=8.2315e-13 ad=1.08875e-13 ps=3.67e-06 pd=9.95e-07 m=1 ng=1 $X=990 $Y=1970 $D=6
M2 2 7 8 1 sg13_lv_pmos w=6.7e-07 l=1.3e-07 as=1.08875e-13 ad=2.278e-13 ps=9.95e-07 pd=2.02e-06 m=1 ng=1 $X=1445 $Y=1970 $D=6
M3 3 4 7 3 sg13_lv_nmos w=4.4e-07 l=1.3e-07 as=1.518e-13 ad=4.51783e-13 ps=1.57e-06 pd=2.67333e-06 m=1 ng=1 $X=450 $Y=910 $D=10
M4 2 5 3 3 sg13_lv_nmos w=4.4e-07 l=1.3e-07 as=6.77675e-13 ad=5.57333e-14 ps=4.01e-06 pd=5.46667e-07 m=1 ng=1 $X=990 $Y=910 $D=10
M5 3 7 2 3 sg13_lv_nmos w=4.4e-07 l=1.3e-07 as=8.36e-14 ad=4.51783e-13 ps=8.2e-07 pd=2.67333e-06 m=1 ng=1 $X=1500 $Y=910 $D=10
.ENDS
***************************************
.SUBCKT EN3JIX0 1 2 3 4 5 6
** N=16 EP=6 IP=0 FDC=20
M0 8 4 1 1 sg13_lv_pmos w=6.6e-07 l=1.3e-07 as=1.07505e-12 ad=2.97e-14 ps=7.26778e-06 pd=4.2e-07 m=1 ng=1 $X=365 $Y=1970 $D=6
M1 9 5 8 1 sg13_lv_pmos w=6.6e-07 l=1.3e-07 as=5.94e-14 ad=1.848e-13 ps=8.4e-07 pd=2e-06 m=1 ng=1 $X=675 $Y=1970 $D=6
M2 1 4 10 1 sg13_lv_pmos w=6.6e-07 l=1.3e-07 as=1.9305e-13 ad=5.37525e-13 ps=2e-06 pd=3.63389e-06 m=1 ng=1 $X=1585 $Y=2220 $D=6
M3 10 5 1 1 sg13_lv_pmos w=6.6e-07 l=1.3e-07 as=1.07505e-12 ad=6.27e-14 ps=7.26778e-06 pd=5.2e-07 m=1 ng=1 $X=2045 $Y=2220 $D=6
M4 11 9 10 1 sg13_lv_pmos w=6.6e-07 l=1.3e-07 as=1.254e-13 ad=1.8435e-13 ps=1.04e-06 pd=1.98243e-06 m=1 ng=1 $X=2555 $Y=2220 $D=6
M5 12 6 1 1 sg13_lv_pmos w=6.6e-07 l=1.3e-07 as=5.37525e-13 ad=1.254e-13 ps=3.63389e-06 pd=1.04e-06 m=1 ng=1 $X=3475 $Y=2130 $D=6
M6 1 11 12 1 sg13_lv_pmos w=6.6e-07 l=1.3e-07 as=1.254e-13 ad=2.268e-13 ps=1.04e-06 pd=1.62e-06 m=1 ng=1 $X=3985 $Y=2130 $D=6
M7 13 6 1 1 sg13_lv_pmos w=6.6e-07 l=1.3e-07 as=2.268e-13 ad=5.94e-14 ps=1.62e-06 pd=8.4e-07 m=1 ng=1 $X=4575 $Y=2130 $D=6
M8 3 11 13 1 sg13_lv_pmos w=6.6e-07 l=1.3e-07 as=5.94e-14 ad=1.254e-13 ps=8.4e-07 pd=1.04e-06 m=1 ng=1 $X=4885 $Y=2130 $D=6
M9 1 12 3 1 sg13_lv_pmos w=6.6e-07 l=1.3e-07 as=1.254e-13 ad=7.445e-13 ps=1.04e-06 pd=5.12e-06 m=1 ng=1 $X=5395 $Y=2130 $D=6
M10 9 4 2 2 sg13_lv_nmos w=4.4e-07 l=1.3e-07 as=2.074e-13 ad=9.24e-14 ps=2.64e-06 pd=8.6e-07 m=1 ng=1 $X=365 $Y=790 $D=10
M11 2 5 9 2 sg13_lv_nmos w=4.4e-07 l=1.3e-07 as=9.24e-14 ad=1.2665e-13 ps=8.6e-07 pd=1.12e-06 m=1 ng=1 $X=915 $Y=790 $D=10
M12 14 4 2 2 sg13_lv_nmos w=4.4e-07 l=1.3e-07 as=1.2665e-13 ad=3.96e-14 ps=1.12e-06 pd=6.2e-07 m=1 ng=1 $X=1455 $Y=520 $D=10
M13 11 5 14 2 sg13_lv_nmos w=4.4e-07 l=1.3e-07 as=3.96e-14 ad=8.36e-14 ps=6.2e-07 pd=8.2e-07 m=1 ng=1 $X=1765 $Y=520 $D=10
M14 2 9 11 2 sg13_lv_nmos w=4.4e-07 l=1.3e-07 as=8.36e-14 ad=2.50525e-13 ps=8.2e-07 pd=1.755e-06 m=1 ng=1 $X=2275 $Y=520 $D=10
M15 15 6 2 2 sg13_lv_nmos w=4.4e-07 l=1.3e-07 as=2.50525e-13 ad=3.96e-14 ps=1.755e-06 pd=6.2e-07 m=1 ng=1 $X=2990 $Y=900 $D=10
M16 12 11 15 2 sg13_lv_nmos w=4.4e-07 l=1.3e-07 as=3.96e-14 ad=1.496e-13 ps=6.2e-07 pd=1.56e-06 m=1 ng=1 $X=3300 $Y=900 $D=10
M17 2 6 16 2 sg13_lv_nmos w=4.4e-07 l=1.3e-07 as=1.562e-13 ad=1.011e-13 ps=1.59e-06 pd=1.07e-06 m=1 ng=1 $X=4335 $Y=470 $D=10
M18 16 11 2 2 sg13_lv_nmos w=4.4e-07 l=1.3e-07 as=1.011e-13 ad=8.36e-14 ps=1.07e-06 pd=8.2e-07 m=1 ng=1 $X=4795 $Y=470 $D=10
M19 3 12 16 2 sg13_lv_nmos w=4.4e-07 l=1.3e-07 as=8.36e-14 ad=1.496e-13 ps=8.2e-07 pd=1.56e-06 m=1 ng=1 $X=5305 $Y=470 $D=10
.ENDS
***************************************
.SUBCKT AND2JIX0 1 2 3 4 5
** N=8 EP=5 IP=0 FDC=6
M0 7 4 1 1 sg13_lv_pmos w=6.7e-07 l=1.3e-07 as=9.876e-13 ad=8.48667e-14 ps=4.77e-06 pd=7e-07 m=1 ng=1 $X=385 $Y=1970 $D=6
M1 1 5 7 1 sg13_lv_pmos w=6.7e-07 l=1.3e-07 as=1.273e-13 ad=6.584e-13 ps=1.05e-06 pd=3.18e-06 m=1 ng=1 $X=895 $Y=1970 $D=6
M2 2 7 1 1 sg13_lv_pmos w=6.7e-07 l=1.3e-07 as=6.584e-13 ad=2.278e-13 ps=3.18e-06 pd=2.02e-06 m=1 ng=1 $X=1525 $Y=1970 $D=6
M3 8 4 7 3 sg13_lv_nmos w=4.4e-07 l=1.3e-07 as=1.496e-13 ad=4.4e-14 ps=1.56e-06 pd=6.4e-07 m=1 ng=1 $X=445 $Y=910 $D=10
M4 3 5 8 3 sg13_lv_nmos w=4.4e-07 l=1.3e-07 as=4.4e-14 ad=6.413e-13 ps=6.4e-07 pd=3.24e-06 m=1 ng=1 $X=775 $Y=910 $D=10
M5 2 7 3 3 sg13_lv_nmos w=4.4e-07 l=1.3e-07 as=6.413e-13 ad=1.496e-13 ps=3.24e-06 pd=1.56e-06 m=1 ng=1 $X=1525 $Y=910 $D=10
.ENDS
***************************************
.SUBCKT SDFRQJIX1 1 2 3 4 5 6 7
** N=27 EP=7 IP=0 FDC=34
M0 1 4 9 1 sg13_lv_pmos w=5.5e-07 l=1.3e-07 as=1.87e-13 ad=2.4045e-13 ps=1.78e-06 pd=1.66e-06 m=1 ng=1 $X=445 $Y=2760 $D=6
M1 10 9 1 1 sg13_lv_pmos w=6.4e-07 l=1.3e-07 as=2.4045e-13 ad=5.76e-14 ps=1.66e-06 pd=8.2e-07 m=1 ng=1 $X=1355 $Y=2430 $D=6
M2 11 5 10 1 sg13_lv_pmos w=6.4e-07 l=1.3e-07 as=5.76e-14 ad=1.232e-13 ps=8.2e-07 pd=1.025e-06 m=1 ng=1 $X=1665 $Y=2430 $D=6
M3 12 6 11 1 sg13_lv_pmos w=6.4e-07 l=1.3e-07 as=1.232e-13 ad=5.76e-14 ps=1.025e-06 pd=8.2e-07 m=1 ng=1 $X=2180 $Y=2430 $D=6
M4 1 4 12 1 sg13_lv_pmos w=6.4e-07 l=1.3e-07 as=5.76e-14 ad=2.70908e-13 ps=8.2e-07 pd=2.09667e-06 m=1 ng=1 $X=2490 $Y=2430 $D=6
M5 13 15 1 1 sg13_lv_pmos w=6.4e-07 l=1.3e-07 as=8.12725e-13 ad=6.08625e-14 ps=6.29e-06 pd=6.53166e-07 m=1 ng=1 $X=2980 $Y=2240 $D=6
M6 14 13 1 1 sg13_lv_pmos w=3e-07 l=1.3e-07 as=2.70908e-13 ad=2.7e-14 ps=2.09667e-06 pd=4.8e-07 m=1 ng=1 $X=3815 $Y=2680 $D=6
M7 15 17 14 1 sg13_lv_pmos w=3e-07 l=1.3e-07 as=2.7e-14 ad=9.84e-14 ps=4.8e-07 pd=1.04e-06 m=1 ng=1 $X=4125 $Y=2680 $D=6
M8 11 16 15 1 sg13_lv_pmos w=6.6e-07 l=1.3e-07 as=9.84e-14 ad=2.029e-13 ps=1.04e-06 pd=2.06e-06 m=1 ng=1 $X=4635 $Y=2410 $D=6
M9 1 17 16 1 sg13_lv_pmos w=5.4e-07 l=1.3e-07 as=1.57e-13 ad=2.19983e-13 ps=1.74828e-06 pd=1.83667e-06 m=1 ng=1 $X=5435 $Y=1930 $D=6
M10 17 7 1 1 sg13_lv_pmos w=5.4e-07 l=1.3e-07 as=6.5995e-13 ad=5.60667e-14 ps=5.51e-06 pd=5.86667e-07 m=1 ng=1 $X=5905 $Y=1945 $D=6
M11 18 13 1 1 sg13_lv_pmos w=6.1e-07 l=1.3e-07 as=2.19983e-13 ad=5.49e-14 ps=1.83667e-06 pd=7.9e-07 m=1 ng=1 $X=6680 $Y=2590 $D=6
M12 19 17 18 1 sg13_lv_pmos w=6.1e-07 l=1.3e-07 as=5.49e-14 ad=9.8075e-14 ps=7.9e-07 pd=9.9e-07 m=1 ng=1 $X=6990 $Y=2590 $D=6
M13 20 16 19 1 sg13_lv_pmos w=3e-07 l=1.3e-07 as=9.8075e-14 ad=2.7e-14 ps=9.9e-07 pd=4.8e-07 m=1 ng=1 $X=7500 $Y=2590 $D=6
M14 1 21 20 1 sg13_lv_pmos w=3e-07 l=1.3e-07 as=2.7e-14 ad=3.71e-13 ps=4.8e-07 pd=2.10333e-06 m=1 ng=1 $X=7810 $Y=2590 $D=6
M15 1 19 21 1 sg13_lv_pmos w=6.4e-07 l=1.3e-07 as=1.923e-13 ad=3.71e-13 ps=1.96e-06 pd=2.10333e-06 m=1 ng=1 $X=8610 $Y=1970 $D=6
M16 3 19 1 1 sg13_lv_pmos w=1.34e-06 l=1.3e-07 as=3.71e-13 ad=4.556e-13 ps=2.10333e-06 pd=3.36e-06 m=1 ng=1 $X=9085 $Y=1970 $D=6
M17 9 4 2 2 sg13_lv_nmos w=3.6e-07 l=1.3e-07 as=2.985e-13 ad=1.224e-13 ps=3.16e-06 pd=1.4e-06 m=1 ng=1 $X=355 $Y=990 $D=10
M18 22 9 2 2 sg13_lv_nmos w=3.85e-07 l=1.3e-07 as=1.63325e-13 ad=3.465e-14 ps=1.75e-06 pd=5.65e-07 m=1 ng=1 $X=1310 $Y=470 $D=10
M19 23 4 2 2 sg13_lv_nmos w=3.85e-07 l=1.3e-07 as=1.63325e-13 ad=3.465e-14 ps=1.75e-06 pd=5.65e-07 m=1 ng=1 $X=1380 $Y=1395 $D=10
M20 24 6 22 2 sg13_lv_nmos w=3.85e-07 l=1.3e-07 as=3.465e-14 ad=1.63325e-13 ps=5.65e-07 pd=1.75e-06 m=1 ng=1 $X=1620 $Y=470 $D=10
M21 24 5 23 2 sg13_lv_nmos w=3.85e-07 l=1.3e-07 as=3.465e-14 ad=1.63325e-13 ps=5.65e-07 pd=1.75e-06 m=1 ng=1 $X=1690 $Y=1395 $D=10
M22 2 15 13 2 sg13_lv_nmos w=8e-07 l=1.3e-07 as=3.12e-13 ad=1.495e-13 ps=2.38e-06 pd=1.46e-06 m=1 ng=1 $X=2830 $Y=470 $D=10
M23 25 13 2 2 sg13_lv_nmos w=3e-07 l=1.3e-07 as=1.495e-13 ad=2.7e-14 ps=1.46e-06 pd=4.8e-07 m=1 ng=1 $X=3320 $Y=470 $D=10
M24 15 16 25 2 sg13_lv_nmos w=3e-07 l=1.3e-07 as=2.7e-14 ad=1.04375e-13 ps=4.8e-07 pd=1.03e-06 m=1 ng=1 $X=3630 $Y=470 $D=10
M25 24 17 15 2 sg13_lv_nmos w=4e-07 l=1.3e-07 as=1.04375e-13 ad=1.715e-13 ps=1.03e-06 pd=2.03e-06 m=1 ng=1 $X=4200 $Y=660 $D=10
M26 2 17 16 2 sg13_lv_nmos w=3.2e-07 l=1.3e-07 as=1.088e-13 ad=2.34483e-13 ps=1.32e-06 pd=1.79667e-06 m=1 ng=1 $X=5110 $Y=990 $D=10
M27 17 7 2 2 sg13_lv_nmos w=3.2e-07 l=1.3e-07 as=7.0345e-13 ad=3.62667e-14 ps=5.39e-06 pd=4.4e-07 m=1 ng=1 $X=5570 $Y=865 $D=10
M28 26 13 2 2 sg13_lv_nmos w=3.6e-07 l=1.3e-07 as=2.34483e-13 ad=3.24e-14 ps=1.79667e-06 pd=5.4e-07 m=1 ng=1 $X=6480 $Y=470 $D=10
M29 19 16 26 2 sg13_lv_nmos w=3.6e-07 l=1.3e-07 as=3.24e-14 ad=6.54e-14 ps=5.4e-07 pd=7.4e-07 m=1 ng=1 $X=6790 $Y=470 $D=10
M30 27 17 19 2 sg13_lv_nmos w=3e-07 l=1.3e-07 as=6.54e-14 ad=2.7e-14 ps=7.4e-07 pd=4.8e-07 m=1 ng=1 $X=7300 $Y=530 $D=10
M31 2 21 27 2 sg13_lv_nmos w=3e-07 l=1.3e-07 as=2.7e-14 ad=1.037e-13 ps=4.8e-07 pd=1.14e-06 m=1 ng=1 $X=7610 $Y=530 $D=10
M32 21 19 2 2 sg13_lv_nmos w=5e-07 l=1.3e-07 as=1.037e-13 ad=1.75e-13 ps=1.14e-06 pd=1.7e-06 m=1 ng=1 $X=8080 $Y=470 $D=10
M33 3 19 2 2 sg13_lv_nmos w=8.8e-07 l=1.3e-07 as=3.507e-13 ad=2.992e-13 ps=2.99e-06 pd=2.44e-06 m=1 ng=1 $X=9085 $Y=470 $D=10
.ENDS
***************************************
.SUBCKT NO2JIX0 1 2 3 4 5
** N=7 EP=5 IP=0 FDC=4
M0 7 4 1 1 sg13_lv_pmos w=6.7e-07 l=1.3e-07 as=1.43645e-12 ad=6.03e-14 ps=6.36e-06 pd=8.5e-07 m=1 ng=1 $X=570 $Y=1970 $D=6
M1 2 5 7 1 sg13_lv_pmos w=6.7e-07 l=1.3e-07 as=6.03e-14 ad=2.278e-13 ps=8.5e-07 pd=2.02e-06 m=1 ng=1 $X=880 $Y=1970 $D=6
M2 2 4 3 3 sg13_lv_nmos w=4.4e-07 l=1.3e-07 as=6.212e-13 ad=8.36e-14 ps=3.5e-06 pd=8.2e-07 m=1 ng=1 $X=570 $Y=910 $D=10
M3 3 5 2 3 sg13_lv_nmos w=4.4e-07 l=1.3e-07 as=8.36e-14 ad=6.212e-13 ps=8.2e-07 pd=3.5e-06 m=1 ng=1 $X=1080 $Y=910 $D=10
.ENDS
***************************************
.SUBCKT ICV_14 1 2 3 4 5 6 7 8 9 10 11 12 13
*.CALIBRE ICV_CELL 9
** N=14 EP=13 IP=18 FDC=76
X0 2 1 8 3 4 5 6 7 SDFRRQJIX1 $T=0 0 0 0 $X=-300 $Y=-260
X1 2 1 13 9 10 11 6 12 SDFRRQJIX1 $T=10920 0 0 0 $X=10620 $Y=-260
.ENDS
***************************************
.SUBCKT EO3JIX0 1 2 3 4 5 6
** N=16 EP=6 IP=0 FDC=20
M0 8 4 1 1 sg13_lv_pmos w=6.6e-07 l=1.3e-07 as=1.63836e-12 ad=1.98e-14 ps=1.15e-05 pd=2.8e-07 m=1 ng=1 $X=365 $Y=1970 $D=6
M1 9 5 8 1 sg13_lv_pmos w=6.6e-07 l=1.3e-07 as=5.94e-14 ad=1.9305e-13 ps=8.4e-07 pd=2e-06 m=1 ng=1 $X=675 $Y=1970 $D=6
M2 1 4 10 1 sg13_lv_pmos w=6.6e-07 l=1.3e-07 as=1.9305e-13 ad=5.46121e-13 ps=2e-06 pd=3.83333e-06 m=1 ng=1 $X=1585 $Y=2270 $D=6
M3 10 5 1 1 sg13_lv_pmos w=6.6e-07 l=1.3e-07 as=1.63836e-12 ad=4.18e-14 ps=1.15e-05 pd=3.46667e-07 m=1 ng=1 $X=2045 $Y=2270 $D=6
M4 11 9 10 1 sg13_lv_pmos w=6.6e-07 l=1.3e-07 as=1.254e-13 ad=2.244e-13 ps=1.04e-06 pd=2e-06 m=1 ng=1 $X=2555 $Y=2270 $D=6
M5 12 6 1 1 sg13_lv_pmos w=6.6e-07 l=1.3e-07 as=1.63836e-12 ad=1.98e-14 ps=1.15e-05 pd=2.8e-07 m=1 ng=1 $X=3495 $Y=2095 $D=6
M6 13 11 12 1 sg13_lv_pmos w=6.6e-07 l=1.3e-07 as=5.94e-14 ad=1.848e-13 ps=8.4e-07 pd=2e-06 m=1 ng=1 $X=3805 $Y=2095 $D=6
M7 1 6 14 1 sg13_lv_pmos w=6.6e-07 l=1.3e-07 as=1.848e-13 ad=5.46121e-13 ps=2e-06 pd=3.83333e-06 m=1 ng=1 $X=4715 $Y=2220 $D=6
M8 14 11 1 1 sg13_lv_pmos w=6.6e-07 l=1.3e-07 as=5.46121e-13 ad=1.254e-13 ps=3.83333e-06 pd=1.04e-06 m=1 ng=1 $X=5215 $Y=2220 $D=6
M9 2 13 14 1 sg13_lv_pmos w=6.6e-07 l=1.3e-07 as=1.254e-13 ad=2.244e-13 ps=1.04e-06 pd=2e-06 m=1 ng=1 $X=5725 $Y=2220 $D=6
M10 9 4 3 3 sg13_lv_nmos w=4.4e-07 l=1.3e-07 as=2.254e-13 ad=9.24e-14 ps=2.88e-06 pd=8.6e-07 m=1 ng=1 $X=365 $Y=910 $D=10
M11 3 5 9 3 sg13_lv_nmos w=4.4e-07 l=1.3e-07 as=9.24e-14 ad=1.3745e-13 ps=8.6e-07 pd=1.2e-06 m=1 ng=1 $X=915 $Y=910 $D=10
M12 15 4 3 3 sg13_lv_nmos w=4.4e-07 l=1.3e-07 as=1.3745e-13 ad=3.96e-14 ps=1.2e-06 pd=6.2e-07 m=1 ng=1 $X=1455 $Y=560 $D=10
M13 11 5 15 3 sg13_lv_nmos w=4.4e-07 l=1.3e-07 as=3.96e-14 ad=8.36e-14 ps=6.2e-07 pd=8.2e-07 m=1 ng=1 $X=1765 $Y=560 $D=10
M14 3 9 11 3 sg13_lv_nmos w=4.4e-07 l=1.3e-07 as=8.36e-14 ad=2.48325e-13 ps=8.2e-07 pd=1.755e-06 m=1 ng=1 $X=2275 $Y=560 $D=10
M15 13 6 3 3 sg13_lv_nmos w=4.4e-07 l=1.3e-07 as=2.48325e-13 ad=8.36e-14 ps=1.755e-06 pd=8.2e-07 m=1 ng=1 $X=2990 $Y=900 $D=10
M16 3 11 13 3 sg13_lv_nmos w=4.4e-07 l=1.3e-07 as=8.36e-14 ad=3.23825e-13 ps=8.2e-07 pd=1.995e-06 m=1 ng=1 $X=3500 $Y=900 $D=10
M17 16 6 3 3 sg13_lv_nmos w=4.4e-07 l=1.3e-07 as=3.23825e-13 ad=3.96e-14 ps=1.995e-06 pd=6.2e-07 m=1 ng=1 $X=4755 $Y=470 $D=10
M18 2 11 16 3 sg13_lv_nmos w=4.4e-07 l=1.3e-07 as=3.96e-14 ad=8.36e-14 ps=6.2e-07 pd=8.2e-07 m=1 ng=1 $X=5065 $Y=470 $D=10
M19 3 13 2 3 sg13_lv_nmos w=4.4e-07 l=1.3e-07 as=8.36e-14 ad=3.416e-13 ps=8.2e-07 pd=2.46e-06 m=1 ng=1 $X=5575 $Y=470 $D=10
.ENDS
***************************************
.SUBCKT NA3I1JIX0 1 2 3 4 5 6
** N=10 EP=6 IP=0 FDC=8
M0 2 4 8 2 sg13_lv_pmos w=6.7e-07 l=1.3e-07 as=2.278e-13 ad=5.16775e-13 ps=2.02e-06 pd=2.62e-06 m=1 ng=1 $X=445 $Y=1970 $D=6
M1 1 5 2 2 sg13_lv_pmos w=6.7e-07 l=1.3e-07 as=1.03355e-12 ad=6.365e-14 ps=5.24e-06 pd=5.25e-07 m=1 ng=1 $X=925 $Y=1970 $D=6
M2 2 6 1 2 sg13_lv_pmos w=6.7e-07 l=1.3e-07 as=1.273e-13 ad=5.16775e-13 ps=1.05e-06 pd=2.62e-06 m=1 ng=1 $X=1435 $Y=1970 $D=6
M3 1 8 2 2 sg13_lv_pmos w=6.7e-07 l=1.3e-07 as=5.16775e-13 ad=2.479e-13 ps=2.62e-06 pd=2.08e-06 m=1 ng=1 $X=1915 $Y=1970 $D=6
M4 3 4 8 3 sg13_lv_nmos w=4.4e-07 l=1.3e-07 as=1.496e-13 ad=6.521e-13 ps=1.56e-06 pd=3.63e-06 m=1 ng=1 $X=445 $Y=910 $D=10
M5 9 5 3 3 sg13_lv_nmos w=4.4e-07 l=1.3e-07 as=6.521e-13 ad=6.49e-14 ps=3.63e-06 pd=7.35e-07 m=1 ng=1 $X=965 $Y=910 $D=10
M6 10 6 9 3 sg13_lv_nmos w=4.4e-07 l=1.3e-07 as=6.49e-14 ad=6.93e-14 ps=7.35e-07 pd=7.55e-07 m=1 ng=1 $X=1390 $Y=910 $D=10
M7 1 8 10 3 sg13_lv_nmos w=4.4e-07 l=1.3e-07 as=6.93e-14 ad=1.98e-13 ps=7.55e-07 pd=1.78e-06 m=1 ng=1 $X=1835 $Y=910 $D=10
.ENDS
***************************************
.SUBCKT NA2I1JIX1 1 2 3 4 5
** N=8 EP=5 IP=0 FDC=6
M0 1 4 7 1 sg13_lv_pmos w=6.7e-07 l=1.3e-07 as=2.3115e-13 ad=4.78412e-13 ps=2.03e-06 pd=2.595e-06 m=1 ng=1 $X=450 $Y=1970 $D=6
M1 3 5 1 1 sg13_lv_pmos w=1.34e-06 l=1.3e-07 as=4.78412e-13 ad=2.546e-13 ps=2.595e-06 pd=1.72e-06 m=1 ng=1 $X=990 $Y=1970 $D=6
M2 1 7 3 1 sg13_lv_pmos w=1.34e-06 l=1.3e-07 as=2.546e-13 ad=5.686e-13 ps=1.72e-06 pd=4.01e-06 m=1 ng=1 $X=1500 $Y=1970 $D=6
M3 2 4 7 2 sg13_lv_nmos w=4.4e-07 l=1.3e-07 as=1.518e-13 ad=3.63525e-13 ps=1.57e-06 pd=2.195e-06 m=1 ng=1 $X=450 $Y=910 $D=10
M4 8 5 2 2 sg13_lv_nmos w=8.8e-07 l=1.3e-07 as=3.63525e-13 ad=1.1e-13 ps=2.195e-06 pd=1.13e-06 m=1 ng=1 $X=1050 $Y=470 $D=10
M5 3 7 8 2 sg13_lv_nmos w=8.8e-07 l=1.3e-07 as=1.1e-13 ad=3.828e-13 ps=1.13e-06 pd=2.63e-06 m=1 ng=1 $X=1430 $Y=470 $D=10
.ENDS
***************************************
.SUBCKT DECAP25JI 1 2
** N=5 EP=2 IP=0 FDC=10
M0 1 5 1 1 sg13_lv_pmos w=1.34e-06 l=2e-06 as=5.94e-13 ad=2.496e-13 ps=4.03e-06 pd=1.97e-06 m=1 ng=1 $X=480 $Y=1970 $D=6
M1 1 5 1 1 sg13_lv_pmos w=1.34e-06 l=2e-06 as=2.496e-13 ad=2.496e-13 ps=1.97e-06 pd=1.97e-06 m=1 ng=1 $X=2810 $Y=1970 $D=6
M2 1 5 1 1 sg13_lv_pmos w=1.34e-06 l=2e-06 as=2.496e-13 ad=2.496e-13 ps=1.97e-06 pd=1.97e-06 m=1 ng=1 $X=5140 $Y=1970 $D=6
M3 1 5 1 1 sg13_lv_pmos w=1.34e-06 l=2e-06 as=2.496e-13 ad=2.44e-13 ps=1.97e-06 pd=1.97e-06 m=1 ng=1 $X=7470 $Y=1970 $D=6
M4 4 5 1 1 sg13_lv_pmos w=1.18e-06 l=1.3e-07 as=2.44e-13 ad=5.487e-13 ps=1.97e-06 pd=3.29e-06 m=1 ng=1 $X=9800 $Y=2130 $D=6
M5 2 4 5 2 sg13_lv_nmos w=7.6e-07 l=1.3e-07 as=3.534e-13 ad=1.695e-13 ps=2.45e-06 pd=1.51e-06 m=1 ng=1 $X=570 $Y=470 $D=10
M6 2 4 2 2 sg13_lv_nmos w=8.8e-07 l=2e-06 as=1.695e-13 ad=1.737e-13 ps=1.51e-06 pd=1.51e-06 m=1 ng=1 $X=1030 $Y=470 $D=10
M7 2 4 2 2 sg13_lv_nmos w=8.8e-07 l=2e-06 as=1.737e-13 ad=1.737e-13 ps=1.51e-06 pd=1.51e-06 m=1 ng=1 $X=3360 $Y=470 $D=10
M8 2 4 2 2 sg13_lv_nmos w=8.8e-07 l=2e-06 as=1.737e-13 ad=1.737e-13 ps=1.51e-06 pd=1.51e-06 m=1 ng=1 $X=5690 $Y=470 $D=10
M9 2 4 2 2 sg13_lv_nmos w=8.8e-07 l=2e-06 as=1.737e-13 ad=4.215e-13 ps=1.51e-06 pd=3.11e-06 m=1 ng=1 $X=8020 $Y=470 $D=10
.ENDS
***************************************
.SUBCKT NO2I1JIX1 1 2 3 4 5
** N=8 EP=5 IP=0 FDC=6
M0 1 4 7 1 sg13_lv_pmos w=6.7e-07 l=1.3e-07 as=2.3115e-13 ad=4.78412e-13 ps=2.03e-06 pd=2.595e-06 m=1 ng=1 $X=450 $Y=1970 $D=6
M1 8 5 1 1 sg13_lv_pmos w=1.34e-06 l=1.3e-07 as=4.78412e-13 ad=2.1775e-13 ps=2.595e-06 pd=1.665e-06 m=1 ng=1 $X=990 $Y=1970 $D=6
M2 2 7 8 1 sg13_lv_pmos w=1.34e-06 l=1.3e-07 as=2.1775e-13 ad=4.556e-13 ps=1.665e-06 pd=3.36e-06 m=1 ng=1 $X=1445 $Y=1970 $D=6
M3 3 4 7 3 sg13_lv_nmos w=4.4e-07 l=1.3e-07 as=1.518e-13 ad=3.28125e-13 ps=1.57e-06 pd=2.135e-06 m=1 ng=1 $X=450 $Y=910 $D=10
M4 2 5 3 3 sg13_lv_nmos w=8.8e-07 l=1.3e-07 as=3.28125e-13 ad=1.672e-13 ps=2.135e-06 pd=1.26e-06 m=1 ng=1 $X=990 $Y=470 $D=10
M5 3 7 2 3 sg13_lv_nmos w=8.8e-07 l=1.3e-07 as=1.672e-13 ad=4.097e-13 ps=1.26e-06 pd=3.09e-06 m=1 ng=1 $X=1500 $Y=470 $D=10
.ENDS
***************************************
.SUBCKT AN22JIX0 1 2 3 4 5 6 7
** N=11 EP=7 IP=0 FDC=8
M0 1 4 9 1 sg13_lv_pmos w=6.7e-07 l=1.3e-07 as=2.278e-13 ad=6.664e-13 ps=2.02e-06 pd=3.85e-06 m=1 ng=1 $X=445 $Y=2210 $D=6
M1 9 5 1 1 sg13_lv_pmos w=6.7e-07 l=1.3e-07 as=6.664e-13 ad=1.273e-13 ps=3.85e-06 pd=1.05e-06 m=1 ng=1 $X=925 $Y=2210 $D=6
M2 2 6 9 1 sg13_lv_pmos w=6.7e-07 l=1.3e-07 as=1.273e-13 ad=1.273e-13 ps=1.05e-06 pd=1.05e-06 m=1 ng=1 $X=1435 $Y=2210 $D=6
M3 9 7 2 1 sg13_lv_pmos w=6.7e-07 l=1.3e-07 as=1.273e-13 ad=2.278e-13 ps=1.05e-06 pd=2.02e-06 m=1 ng=1 $X=1945 $Y=2210 $D=6
M4 10 4 3 3 sg13_lv_nmos w=4.4e-07 l=1.3e-07 as=8.0465e-13 ad=5.5e-14 ps=4.32e-06 pd=6.9e-07 m=1 ng=1 $X=575 $Y=880 $D=10
M5 2 5 10 3 sg13_lv_nmos w=4.4e-07 l=1.3e-07 as=5.5e-14 ad=8.36e-14 ps=6.9e-07 pd=8.2e-07 m=1 ng=1 $X=955 $Y=880 $D=10
M6 11 6 2 3 sg13_lv_nmos w=4.4e-07 l=1.3e-07 as=8.36e-14 ad=5.5e-14 ps=8.2e-07 pd=6.9e-07 m=1 ng=1 $X=1465 $Y=880 $D=10
M7 3 7 11 3 sg13_lv_nmos w=4.4e-07 l=1.3e-07 as=5.5e-14 ad=8.0465e-13 ps=6.9e-07 pd=4.32e-06 m=1 ng=1 $X=1845 $Y=880 $D=10
.ENDS
***************************************
.SUBCKT NA4JIX0 1 2 3 4 5 6
** N=11 EP=6 IP=0 FDC=8
M0 8 3 1 1 sg13_lv_pmos w=6.7e-07 l=1.3e-07 as=1.23832e-12 ad=6.365e-14 ps=6.145e-06 pd=5.25e-07 m=1 ng=1 $X=385 $Y=1970 $D=6
M1 1 4 8 1 sg13_lv_pmos w=6.7e-07 l=1.3e-07 as=1.273e-13 ad=6.19162e-13 ps=1.05e-06 pd=3.0725e-06 m=1 ng=1 $X=895 $Y=1970 $D=6
M2 8 5 1 1 sg13_lv_pmos w=6.7e-07 l=1.3e-07 as=1.23832e-12 ad=6.78375e-14 ps=6.145e-06 pd=5.375e-07 m=1 ng=1 $X=1375 $Y=1970 $D=6
M3 1 6 8 1 sg13_lv_pmos w=6.7e-07 l=1.3e-07 as=1.35675e-13 ad=6.19162e-13 ps=1.075e-06 pd=3.0725e-06 m=1 ng=1 $X=1910 $Y=1970 $D=6
M4 9 3 2 2 sg13_lv_nmos w=4.4e-07 l=1.3e-07 as=1.3277e-12 ad=6.38e-14 ps=7.1e-06 pd=7.3e-07 m=1 ng=1 $X=505 $Y=900 $D=10
M5 10 4 9 2 sg13_lv_nmos w=4.4e-07 l=1.3e-07 as=6.38e-14 ad=6.82e-14 ps=7.3e-07 pd=7.5e-07 m=1 ng=1 $X=925 $Y=900 $D=10
M6 11 5 10 2 sg13_lv_nmos w=4.4e-07 l=1.3e-07 as=6.82e-14 ad=6.38e-14 ps=7.5e-07 pd=7.3e-07 m=1 ng=1 $X=1365 $Y=900 $D=10
M7 8 6 11 2 sg13_lv_nmos w=4.4e-07 l=1.3e-07 as=6.38e-14 ad=1.496e-13 ps=7.3e-07 pd=1.56e-06 m=1 ng=1 $X=1785 $Y=900 $D=10
.ENDS
***************************************
.SUBCKT ON21JIX0 1 2 3 4 5 6
** N=9 EP=6 IP=0 FDC=6
M0 3 4 2 3 sg13_lv_pmos w=6.7e-07 l=1.3e-07 as=2.278e-13 ad=9.0795e-13 ps=2.02e-06 pd=3.67e-06 m=1 ng=1 $X=445 $Y=1970 $D=6
M1 8 5 3 3 sg13_lv_pmos w=6.7e-07 l=1.3e-07 as=9.0795e-13 ad=8.04e-14 ps=3.67e-06 pd=9.1e-07 m=1 ng=1 $X=1155 $Y=1970 $D=6
M2 2 6 8 3 sg13_lv_pmos w=6.7e-07 l=1.3e-07 as=8.04e-14 ad=2.278e-13 ps=9.1e-07 pd=2.02e-06 m=1 ng=1 $X=1525 $Y=1970 $D=6
M3 9 4 2 1 sg13_lv_nmos w=4.4e-07 l=1.3e-07 as=1.496e-13 ad=2.15467e-13 ps=1.56e-06 pd=2.12e-06 m=1 ng=1 $X=445 $Y=860 $D=10
M4 1 5 9 1 sg13_lv_nmos w=4.4e-07 l=1.3e-07 as=3.232e-13 ad=8.06667e-14 ps=3.18e-06 pd=6.6e-07 m=1 ng=1 $X=915 $Y=860 $D=10
M5 9 6 1 1 sg13_lv_nmos w=4.4e-07 l=1.3e-07 as=1.21e-13 ad=2.15467e-13 ps=9.9e-07 pd=2.12e-06 m=1 ng=1 $X=1595 $Y=860 $D=10
.ENDS
***************************************
.SUBCKT ICV_15 1 2 3 4 5 6 7
*.CALIBRE ICV_CELL 9
** N=8 EP=7 IP=11 FDC=8
X1 2 6 1 3 4 5 7 AN22JIX0 $T=420 0 0 0 $X=120 $Y=-260
.ENDS
***************************************
.SUBCKT AO21JIX0 1 2 3 4 5 6
** N=10 EP=6 IP=0 FDC=8
M0 2 9 1 2 sg13_lv_pmos w=6.7e-07 l=1.3e-07 as=2.278e-13 ad=3.86775e-13 ps=2.02e-06 pd=2.46536e-06 m=1 ng=1 $X=445 $Y=2050 $D=6
M1 8 4 2 2 sg13_lv_pmos w=6.7e-07 l=1.3e-07 as=3.86775e-13 ad=2.05767e-13 ps=2.46536e-06 pd=1.69333e-06 m=1 ng=1 $X=955 $Y=2640 $D=6
M2 8 5 2 2 sg13_lv_pmos w=6.7e-07 l=1.3e-07 as=1.9465e-13 ad=2.05767e-13 ps=1.99071e-06 pd=1.69333e-06 m=1 ng=1 $X=1485 $Y=1760 $D=6
M3 9 6 8 2 sg13_lv_pmos w=6.7e-07 l=1.3e-07 as=2.05767e-13 ad=2.278e-13 ps=1.69333e-06 pd=2.02e-06 m=1 ng=1 $X=1945 $Y=1970 $D=6
M4 3 9 1 3 sg13_lv_nmos w=4.4e-07 l=1.3e-07 as=1.496e-13 ad=4.04517e-13 ps=1.56e-06 pd=2.86e-06 m=1 ng=1 $X=445 $Y=790 $D=10
M5 10 4 3 3 sg13_lv_nmos w=4.4e-07 l=1.3e-07 as=6.06775e-13 ad=2.78667e-14 ps=4.29e-06 pd=4.2e-07 m=1 ng=1 $X=975 $Y=700 $D=10
M6 9 5 10 3 sg13_lv_nmos w=4.4e-07 l=1.3e-07 as=4.18e-14 ad=9.02e-14 ps=6.3e-07 pd=8.5e-07 m=1 ng=1 $X=1295 $Y=700 $D=10
M7 3 6 9 3 sg13_lv_nmos w=4.4e-07 l=1.3e-07 as=9.02e-14 ad=4.04517e-13 ps=8.5e-07 pd=2.86e-06 m=1 ng=1 $X=1835 $Y=700 $D=10
.ENDS
***************************************
.SUBCKT Main
** N=548 EP=0 IP=7749 FDC=6206
M0 2 258 1 2 sg13_lv_pmos w=6.7e-07 l=1.3e-07 as=2.278e-13 ad=4.183e-13 ps=2.02e-06 pd=2.465e-06 m=1 ng=1 $X=57985 $Y=88730 $D=6
M1 1 160 2 2 sg13_lv_pmos w=6.7e-07 l=1.3e-07 as=8.366e-13 ad=6.365e-14 ps=4.93e-06 pd=5.25e-07 m=1 ng=1 $X=58485 $Y=88730 $D=6
M2 2 194 1 2 sg13_lv_pmos w=6.7e-07 l=1.3e-07 as=1.273e-13 ad=4.183e-13 ps=1.05e-06 pd=2.465e-06 m=1 ng=1 $X=58995 $Y=88730 $D=6
M3 3 1 2 2 sg13_lv_pmos w=6.7e-07 l=1.3e-07 as=4.183e-13 ad=2.278e-13 ps=2.465e-06 pd=2.02e-06 m=1 ng=1 $X=59485 $Y=88730 $D=6
M4 5 181 2 2 sg13_lv_pmos w=6.7e-07 l=1.3e-07 as=8.3e-13 ad=8.48667e-14 ps=4.18e-06 pd=7e-07 m=1 ng=1 $X=68005 $Y=91440 $D=6
M5 2 275 5 2 sg13_lv_pmos w=6.7e-07 l=1.3e-07 as=1.273e-13 ad=5.53333e-13 ps=1.05e-06 pd=2.78667e-06 m=1 ng=1 $X=68515 $Y=91440 $D=6
M6 6 5 2 2 sg13_lv_pmos w=1.34e-06 l=1.3e-07 as=5.53333e-13 ad=4.556e-13 ps=2.78667e-06 pd=3.36e-06 m=1 ng=1 $X=69145 $Y=90770 $D=6
M7 7 317 2 2 sg13_lv_pmos w=6.7e-07 l=1.3e-07 as=1.12045e-12 ad=1.273e-13 ps=5.1e-06 pd=1.05e-06 m=1 ng=1 $X=70135 $Y=91440 $D=6
M8 8 289 7 2 sg13_lv_pmos w=6.7e-07 l=1.3e-07 as=1.273e-13 ad=1.139e-13 ps=1.05e-06 pd=1.01e-06 m=1 ng=1 $X=70645 $Y=91440 $D=6
M9 9 177 8 2 sg13_lv_pmos w=6.7e-07 l=1.3e-07 as=1.139e-13 ad=1.1055e-13 ps=1.01e-06 pd=1e-06 m=1 ng=1 $X=71115 $Y=91440 $D=6
M10 2 275 9 2 sg13_lv_pmos w=6.7e-07 l=1.3e-07 as=1.1055e-13 ad=1.12045e-12 ps=1e-06 pd=5.1e-06 m=1 ng=1 $X=71575 $Y=91440 $D=6
M11 2 12 10 2 sg13_lv_pmos w=6.7e-07 l=1.3e-07 as=2.278e-13 ad=4.4775e-13 ps=2.02e-06 pd=2.58e-06 m=1 ng=1 $X=72685 $Y=88490 $D=6
M12 11 177 2 2 sg13_lv_pmos w=6.7e-07 l=1.3e-07 as=4.4775e-13 ad=1.8025e-13 ps=2.58e-06 pd=1.67e-06 m=1 ng=1 $X=73215 $Y=88625 $D=6
M13 2 239 11 2 sg13_lv_pmos w=6.7e-07 l=1.3e-07 as=1.8025e-13 ad=2.07125e-13 ps=1.67e-06 pd=1.895e-06 m=1 ng=1 $X=73675 $Y=88625 $D=6
M14 11 288 2 2 sg13_lv_pmos w=6.7e-07 l=1.3e-07 as=2.07125e-13 ad=2.807e-13 ps=1.895e-06 pd=2.35333e-06 m=1 ng=1 $X=74135 $Y=88625 $D=6
M15 12 291 11 2 sg13_lv_pmos w=6.7e-07 l=1.3e-07 as=4.2105e-13 ad=8.48667e-14 ps=3.53e-06 pd=7e-07 m=1 ng=1 $X=74595 $Y=88625 $D=6
M16 11 194 12 2 sg13_lv_pmos w=6.7e-07 l=1.3e-07 as=1.273e-13 ad=2.807e-13 ps=1.05e-06 pd=2.35333e-06 m=1 ng=1 $X=75105 $Y=88625 $D=6
M17 2 15 13 2 sg13_lv_pmos w=1.34e-06 l=1.3e-07 as=4.556e-13 ad=2.926e-13 ps=3.36e-06 pd=2.07e-06 m=1 ng=1 $X=76465 $Y=73370 $D=6
M18 14 325 2 2 sg13_lv_pmos w=9e-07 l=1.3e-07 as=2.926e-13 ad=8.1e-14 ps=2.07e-06 pd=1.08e-06 m=1 ng=1 $X=77025 $Y=73570 $D=6
M19 15 351 14 2 sg13_lv_pmos w=9e-07 l=1.3e-07 as=8.1e-14 ad=1.71e-13 ps=1.08e-06 pd=1.28e-06 m=1 ng=1 $X=77335 $Y=73570 $D=6
M20 2 17 15 2 sg13_lv_pmos w=9e-07 l=1.3e-07 as=1.71e-13 ad=4.185e-13 ps=1.28e-06 pd=3.09e-06 m=1 ng=1 $X=77845 $Y=73570 $D=6
M21 2 17 16 2 sg13_lv_pmos w=1.1e-06 l=1.3e-07 as=3.85e-13 ad=2.705e-13 ps=2.9e-06 pd=1.83e-06 m=1 ng=1 $X=78965 $Y=73370 $D=6
M22 17 351 2 2 sg13_lv_pmos w=9e-07 l=1.3e-07 as=2.705e-13 ad=1.71e-13 ps=1.83e-06 pd=1.28e-06 m=1 ng=1 $X=79555 $Y=73570 $D=6
M23 2 325 17 2 sg13_lv_pmos w=9e-07 l=1.3e-07 as=1.71e-13 ad=4.356e-13 ps=1.28e-06 pd=3.56e-06 m=1 ng=1 $X=80065 $Y=73570 $D=6
M24 2 379 18 2 sg13_lv_pmos w=1.34e-06 l=1.3e-07 as=4.556e-13 ad=3.398e-13 ps=3.36e-06 pd=2.08e-06 m=1 ng=1 $X=83605 $Y=52970 $D=6
M25 18 382 2 2 sg13_lv_pmos w=1.34e-06 l=1.3e-07 as=3.398e-13 ad=2.546e-13 ps=2.08e-06 pd=1.72e-06 m=1 ng=1 $X=84175 $Y=52970 $D=6
M26 19 388 18 2 sg13_lv_pmos w=1.34e-06 l=1.3e-07 as=2.546e-13 ad=4.556e-13 ps=1.72e-06 pd=3.36e-06 m=1 ng=1 $X=84685 $Y=52970 $D=6
M27 20 422 2 2 sg13_lv_pmos w=1.34e-06 l=1.3e-07 as=6.514e-13 ad=2.546e-13 ps=4.1e-06 pd=1.72e-06 m=1 ng=1 $X=99215 $Y=83210 $D=6
M28 2 443 20 2 sg13_lv_pmos w=1.34e-06 l=1.3e-07 as=2.546e-13 ad=3.726e-13 ps=1.72e-06 pd=2.12e-06 m=1 ng=1 $X=99725 $Y=83210 $D=6
M29 21 460 2 2 sg13_lv_pmos w=1.34e-06 l=1.3e-07 as=3.726e-13 ad=1.206e-13 ps=2.12e-06 pd=1.52e-06 m=1 ng=1 $X=100335 $Y=83210 $D=6
M30 20 463 21 2 sg13_lv_pmos w=1.34e-06 l=1.3e-07 as=1.206e-13 ad=4.556e-13 ps=1.52e-06 pd=3.36e-06 m=1 ng=1 $X=100645 $Y=83210 $D=6
M31 22 258 1 4 sg13_lv_nmos w=4.4e-07 l=1.3e-07 as=1.496e-13 ad=3.96e-14 ps=1.56e-06 pd=6.2e-07 m=1 ng=1 $X=58175 $Y=87430 $D=10
M32 23 160 22 4 sg13_lv_nmos w=4.4e-07 l=1.3e-07 as=3.96e-14 ad=3.96e-14 ps=6.2e-07 pd=6.2e-07 m=1 ng=1 $X=58485 $Y=87430 $D=10
M33 4 194 23 4 sg13_lv_nmos w=4.4e-07 l=1.3e-07 as=3.96e-14 ad=7.1195e-13 ps=6.2e-07 pd=3.71e-06 m=1 ng=1 $X=58795 $Y=87430 $D=10
M34 3 1 4 4 sg13_lv_nmos w=4.4e-07 l=1.3e-07 as=7.1195e-13 ad=1.496e-13 ps=3.71e-06 pd=1.56e-06 m=1 ng=1 $X=59485 $Y=87430 $D=10
M35 24 181 5 4 sg13_lv_nmos w=4.4e-07 l=1.3e-07 as=1.496e-13 ad=4.4e-14 ps=1.56e-06 pd=6.4e-07 m=1 ng=1 $X=68065 $Y=92730 $D=10
M36 4 275 24 4 sg13_lv_nmos w=4.4e-07 l=1.3e-07 as=4.4e-14 ad=5.298e-13 ps=6.4e-07 pd=2.7e-06 m=1 ng=1 $X=68395 $Y=92730 $D=10
M37 6 5 4 4 sg13_lv_nmos w=8.8e-07 l=1.3e-07 as=5.298e-13 ad=2.992e-13 ps=2.7e-06 pd=2.44e-06 m=1 ng=1 $X=69145 $Y=92730 $D=10
M38 25 317 7 4 sg13_lv_nmos w=4.4e-07 l=1.3e-07 as=1.496e-13 ad=1.562e-13 ps=1.56e-06 pd=1.555e-06 m=1 ng=1 $X=70165 $Y=92775 $D=10
M39 4 289 25 4 sg13_lv_nmos w=4.4e-07 l=1.3e-07 as=3.124e-13 ad=4.62e-14 ps=3.11e-06 pd=4.3e-07 m=1 ng=1 $X=70625 $Y=92775 $D=10
M40 25 177 4 4 sg13_lv_nmos w=4.4e-07 l=1.3e-07 as=9.24e-14 ad=1.562e-13 ps=8.6e-07 pd=1.555e-06 m=1 ng=1 $X=71175 $Y=92775 $D=10
M41 4 275 25 4 sg13_lv_nmos w=4.4e-07 l=1.3e-07 as=1.562e-13 ad=3.962e-13 ps=1.555e-06 pd=3.13e-06 m=1 ng=1 $X=71635 $Y=92775 $D=10
M42 4 12 10 4 sg13_lv_nmos w=4.4e-07 l=1.3e-07 as=1.496e-13 ad=6.485e-13 ps=1.56e-06 pd=3.56667e-06 m=1 ng=1 $X=72685 $Y=87430 $D=10
M43 26 177 4 4 sg13_lv_nmos w=4.4e-07 l=1.3e-07 as=9.7275e-13 ad=2.64e-14 ps=5.35e-06 pd=4.13333e-07 m=1 ng=1 $X=73395 $Y=87340 $D=10
M44 27 239 26 4 sg13_lv_nmos w=4.4e-07 l=1.3e-07 as=3.96e-14 ad=3.96e-14 ps=6.2e-07 pd=6.2e-07 m=1 ng=1 $X=73705 $Y=87340 $D=10
M45 12 288 27 4 sg13_lv_nmos w=4.4e-07 l=1.3e-07 as=3.96e-14 ad=1.106e-13 ps=6.2e-07 pd=1e-06 m=1 ng=1 $X=74015 $Y=87340 $D=10
M46 28 291 12 4 sg13_lv_nmos w=4.4e-07 l=1.3e-07 as=1.106e-13 ad=3.96e-14 ps=1e-06 pd=6.2e-07 m=1 ng=1 $X=74615 $Y=87430 $D=10
M47 4 194 28 4 sg13_lv_nmos w=4.4e-07 l=1.3e-07 as=3.96e-14 ad=6.485e-13 ps=6.2e-07 pd=3.56667e-06 m=1 ng=1 $X=74925 $Y=87430 $D=10
M48 4 15 13 4 sg13_lv_nmos w=8.8e-07 l=1.3e-07 as=2.992e-13 ad=3.008e-13 ps=2.44e-06 pd=3.04e-06 m=1 ng=1 $X=76465 $Y=71870 $D=10
M49 4 325 29 4 sg13_lv_nmos w=7.8e-07 l=1.3e-07 as=2.168e-13 ad=1.572e-13 ps=2.24e-06 pd=1.41e-06 m=1 ng=1 $X=77375 $Y=71870 $D=10
M50 29 351 4 4 sg13_lv_nmos w=7.8e-07 l=1.3e-07 as=1.572e-13 ad=1.482e-13 ps=1.41e-06 pd=1.16e-06 m=1 ng=1 $X=77835 $Y=71870 $D=10
M51 15 17 29 4 sg13_lv_nmos w=7.8e-07 l=1.3e-07 as=1.482e-13 ad=2.31287e-13 ps=1.16e-06 pd=2.22536e-06 m=1 ng=1 $X=78345 $Y=71870 $D=10
M52 4 17 16 4 sg13_lv_nmos w=7.8e-07 l=1.3e-07 as=2.17587e-13 ad=1.572e-13 ps=2.22536e-06 pd=1.41e-06 m=1 ng=1 $X=79295 $Y=71870 $D=10
M53 30 351 4 4 sg13_lv_nmos w=7.8e-07 l=1.3e-07 as=1.572e-13 ad=7.02e-14 ps=1.41e-06 pd=9.6e-07 m=1 ng=1 $X=79755 $Y=71870 $D=10
M54 17 325 30 4 sg13_lv_nmos w=7.8e-07 l=1.3e-07 as=7.02e-14 ad=2.652e-13 ps=9.6e-07 pd=2.24e-06 m=1 ng=1 $X=80065 $Y=71870 $D=10
M55 31 379 4 4 sg13_lv_nmos w=8.8e-07 l=1.3e-07 as=5.218e-13 ad=7.92e-14 ps=3.28e-06 pd=1.06e-06 m=1 ng=1 $X=83725 $Y=54930 $D=10
M56 19 382 31 4 sg13_lv_nmos w=8.8e-07 l=1.3e-07 as=7.92e-14 ad=1.672e-13 ps=1.06e-06 pd=1.26e-06 m=1 ng=1 $X=84035 $Y=54930 $D=10
M57 4 388 19 4 sg13_lv_nmos w=8.8e-07 l=1.3e-07 as=1.672e-13 ad=5.454e-13 ps=1.26e-06 pd=3.32e-06 m=1 ng=1 $X=84545 $Y=54930 $D=10
M58 32 422 4 4 sg13_lv_nmos w=8.8e-07 l=1.3e-07 as=4.982e-13 ad=1.1e-13 ps=3.24e-06 pd=1.13e-06 m=1 ng=1 $X=99245 $Y=85170 $D=10
M59 33 443 32 4 sg13_lv_nmos w=8.8e-07 l=1.3e-07 as=1.1e-13 ad=1.672e-13 ps=1.13e-06 pd=1.26e-06 m=1 ng=1 $X=99625 $Y=85170 $D=10
M60 20 460 33 4 sg13_lv_nmos w=8.8e-07 l=1.3e-07 as=1.672e-13 ad=1.672e-13 ps=1.26e-06 pd=1.26e-06 m=1 ng=1 $X=100135 $Y=85170 $D=10
M61 33 463 20 4 sg13_lv_nmos w=8.8e-07 l=1.3e-07 as=1.672e-13 ad=2.992e-13 ps=1.26e-06 pd=2.44e-06 m=1 ng=1 $X=100645 $Y=85170 $D=10
X1363 2 4 DECAP3JI $T=36120 101640 1 0 $X=35820 $Y=97460
X1364 2 4 DECAP3JI $T=36540 56280 1 0 $X=36240 $Y=52100
X1365 2 4 DECAP3JI $T=50820 63840 0 180 $X=49260 $Y=59660
X1366 2 4 DECAP3JI $T=67200 71400 1 0 $X=66900 $Y=67220
X1367 2 4 DECAP3JI $T=76860 78960 1 0 $X=76560 $Y=74780
X1368 2 4 DECAP3JI $T=78120 109200 0 0 $X=77820 $Y=108940
X1369 2 4 DECAP3JI $T=79800 48720 0 0 $X=79500 $Y=48460
X1370 2 4 DECAP3JI $T=83580 78960 1 0 $X=83280 $Y=74780
X1371 2 4 DECAP3JI $T=86520 86520 1 0 $X=86220 $Y=82340
X1372 2 4 DECAP3JI $T=90720 63840 0 0 $X=90420 $Y=63580
X1373 2 4 DECAP3JI $T=98280 41160 1 0 $X=97980 $Y=36980
X1374 2 4 DECAP3JI $T=108360 86520 1 0 $X=108060 $Y=82340
X1375 2 4 DECAP3JI $T=112140 26040 0 0 $X=111840 $Y=25780
X1376 2 4 DECAP3JI $T=112560 33600 0 0 $X=112260 $Y=33340
X1377 2 4 DECAP3JI $T=112560 56280 1 0 $X=112260 $Y=52100
X1378 2 4 DECAP3JI $T=112560 56280 0 0 $X=112260 $Y=56020
X1379 2 4 DECAP3JI $T=112560 109200 0 0 $X=112260 $Y=108940
X1410 2 4 DECAP5JI $T=22260 109200 0 0 $X=21960 $Y=108940
X1411 2 4 DECAP5JI $T=31080 109200 0 0 $X=30780 $Y=108940
X1412 2 4 DECAP5JI $T=34020 86520 1 0 $X=33720 $Y=82340
X1413 2 4 DECAP5JI $T=34440 56280 1 0 $X=34140 $Y=52100
X1414 2 4 DECAP5JI $T=41580 94080 0 0 $X=41280 $Y=93820
X1415 2 4 DECAP5JI $T=42420 48720 1 0 $X=42120 $Y=44540
X1416 2 4 DECAP5JI $T=44940 41160 1 0 $X=44640 $Y=36980
X1417 2 4 DECAP5JI $T=45360 109200 0 0 $X=45060 $Y=108940
X1418 2 4 DECAP5JI $T=54180 63840 1 0 $X=53880 $Y=59660
X1419 2 4 DECAP5JI $T=55020 109200 0 0 $X=54720 $Y=108940
X1420 2 4 DECAP5JI $T=55440 94080 0 0 $X=55140 $Y=93820
X1421 2 4 DECAP5JI $T=61320 109200 0 0 $X=61020 $Y=108940
X1422 2 4 DECAP5JI $T=65520 41160 1 0 $X=65220 $Y=36980
X1423 2 4 DECAP5JI $T=77700 41160 1 180 $X=75300 $Y=40900
X1424 2 4 DECAP5JI $T=75600 86520 0 0 $X=75300 $Y=86260
X1425 2 4 DECAP5JI $T=81480 78960 1 0 $X=81180 $Y=74780
X1426 2 4 DECAP5JI $T=83580 26040 0 0 $X=83280 $Y=25780
X1427 2 4 DECAP5JI $T=88200 48720 0 0 $X=87900 $Y=48460
X1428 2 4 DECAP5JI $T=96600 109200 0 0 $X=96300 $Y=108940
X1429 2 4 DECAP5JI $T=98700 86520 0 0 $X=98400 $Y=86260
X1430 2 4 DECAP5JI $T=110460 33600 0 0 $X=110160 $Y=33340
X1431 2 4 DECAP5JI $T=110880 71400 1 0 $X=110580 $Y=67220
X1432 2 4 DECAP5JI $T=113820 101640 1 180 $X=111420 $Y=101380
X1433 2 38 4 36 BUJIX1 $T=47460 86520 0 0 $X=47160 $Y=86260
X1434 2 121 4 511 BUJIX1 $T=111720 94080 0 0 $X=111420 $Y=93820
X1476 39 2 4 44 6 61 68 AO22JIX0 $T=22260 48720 1 0 $X=21960 $Y=44540
X1477 83 2 4 45 6 61 67 AO22JIX0 $T=22260 48720 0 0 $X=21960 $Y=48460
X1478 43 2 4 46 6 61 69 AO22JIX0 $T=22260 63840 1 0 $X=21960 $Y=59660
X1479 40 2 4 47 6 61 70 AO22JIX0 $T=22260 71400 1 0 $X=21960 $Y=67220
X1480 41 2 4 49 6 61 73 AO22JIX0 $T=22260 94080 0 0 $X=21960 $Y=93820
X1481 42 2 4 50 6 61 74 AO22JIX0 $T=22260 101640 1 0 $X=21960 $Y=97460
X1482 64 2 4 79 6 61 89 AO22JIX0 $T=24360 109200 0 0 $X=24060 $Y=108940
X1483 82 2 4 87 6 61 88 AO22JIX0 $T=26040 86520 0 0 $X=25740 $Y=86260
X1484 102 2 4 105 6 61 119 AO22JIX0 $T=33180 63840 0 0 $X=32880 $Y=63580
X1485 104 2 4 37 6 61 113 AO22JIX0 $T=33180 109200 0 0 $X=32880 $Y=108940
X1486 120 2 4 141 6 61 152 AO22JIX0 $T=38220 109200 0 0 $X=37920 $Y=108940
X1487 139 2 4 144 6 61 126 AO22JIX0 $T=38640 78960 1 0 $X=38340 $Y=74780
X1488 127 2 4 145 6 61 133 AO22JIX0 $T=38640 94080 0 0 $X=38340 $Y=93820
X1489 175 2 4 148 6 61 162 AO22JIX0 $T=47880 101640 1 0 $X=47580 $Y=97460
X1490 172 2 4 158 181 177 518 AO22JIX0 $T=48300 26040 0 0 $X=48000 $Y=25780
X1491 168 2 4 187 181 177 519 AO22JIX0 $T=49560 56280 1 0 $X=49260 $Y=52100
X1492 165 2 4 164 181 177 520 AO22JIX0 $T=50400 41160 1 0 $X=50100 $Y=36980
X1493 178 2 4 189 6 61 195 AO22JIX0 $T=50820 101640 1 0 $X=50520 $Y=97460
X1494 179 2 4 193 181 177 521 AO22JIX0 $T=52080 71400 1 0 $X=51780 $Y=67220
X1495 171 2 4 186 6 61 170 AO22JIX0 $T=55020 101640 0 0 $X=54720 $Y=101380
X1496 173 2 4 159 181 177 522 AO22JIX0 $T=55440 41160 0 0 $X=55140 $Y=40900
X1497 206 2 4 212 6 61 216 AO22JIX0 $T=58380 109200 0 0 $X=58080 $Y=108940
X1498 184 2 4 207 181 177 523 AO22JIX0 $T=59220 71400 1 0 $X=58920 $Y=67220
X1499 218 2 4 249 6 61 213 AO22JIX0 $T=63420 109200 0 0 $X=63120 $Y=108940
X1500 222 2 4 219 6 61 209 AO22JIX0 $T=63840 101640 1 0 $X=63540 $Y=97460
X1501 282 2 4 300 6 61 270 AO22JIX0 $T=70980 109200 0 0 $X=70680 $Y=108940
X1502 287 2 4 327 181 177 524 AO22JIX0 $T=75180 56280 0 0 $X=74880 $Y=56020
X1503 339 2 4 344 181 177 525 AO22JIX0 $T=77280 94080 1 0 $X=76980 $Y=89900
X1504 356 2 4 309 181 177 526 AO22JIX0 $T=81480 78960 0 180 $X=78240 $Y=74780
X1505 354 2 4 359 6 61 202 AO22JIX0 $T=79380 109200 0 0 $X=79080 $Y=108940
X1506 364 2 4 378 6 61 304 AO22JIX0 $T=82320 101640 0 0 $X=82020 $Y=101380
X1507 362 2 4 384 181 177 527 AO22JIX0 $T=83580 86520 1 0 $X=83280 $Y=82340
X1508 353 2 4 396 6 61 292 AO22JIX0 $T=85260 101640 0 0 $X=84960 $Y=101380
X1509 420 2 4 443 181 177 528 AO22JIX0 $T=92820 86520 0 0 $X=92520 $Y=86260
X1510 448 2 4 422 181 177 529 AO22JIX0 $T=95760 86520 0 0 $X=95460 $Y=86260
X1511 477 2 4 503 6 61 310 AO22JIX0 $T=105420 109200 0 0 $X=105120 $Y=108940
X1512 499 2 4 452 181 177 530 AO22JIX0 $T=107520 33600 0 0 $X=107220 $Y=33340
X1513 498 2 4 515 6 61 358 AO22JIX0 $T=110880 109200 1 0 $X=110580 $Y=105020
X1514 2 4 235 211 215 NA2JIX1 $T=59220 33600 1 0 $X=58920 $Y=29420
X1515 2 4 215 256 231 NA2JIX1 $T=60900 63840 1 0 $X=60600 $Y=59660
X1516 2 4 241 234 251 NA2JIX1 $T=61740 33600 0 0 $X=61440 $Y=33340
X1517 2 4 231 224 242 NA2JIX1 $T=62160 63840 0 0 $X=61860 $Y=63580
X1518 2 4 244 193 207 NA2JIX1 $T=62160 71400 1 0 $X=61860 $Y=67220
X1519 2 4 238 240 261 NA2JIX1 $T=63000 48720 1 0 $X=62700 $Y=44540
X1520 2 4 260 250 257 NA2JIX1 $T=64260 71400 0 0 $X=63960 $Y=71140
X1521 2 4 261 254 259 NA2JIX1 $T=64680 48720 1 0 $X=64380 $Y=44540
X1522 2 4 259 244 263 NA2JIX1 $T=65520 71400 1 0 $X=65220 $Y=67220
X1523 2 4 263 260 265 NA2JIX1 $T=65940 71400 0 0 $X=65640 $Y=71140
X1524 2 4 294 296 301 NA2JIX1 $T=70980 63840 0 0 $X=70680 $Y=63580
X1525 2 4 321 302 307 NA2JIX1 $T=71820 41160 0 0 $X=71520 $Y=40900
X1526 2 4 318 299 294 NA2JIX1 $T=71820 56280 0 0 $X=71520 $Y=56020
X1527 2 4 315 303 309 NA2JIX1 $T=72240 71400 0 0 $X=71940 $Y=71140
X1528 2 4 307 316 318 NA2JIX1 $T=73500 56280 0 0 $X=73200 $Y=56020
X1529 2 4 335 295 322 NA2JIX1 $T=74340 33600 0 0 $X=74040 $Y=33340
X1530 2 4 301 16 334 NA2JIX1 $T=75600 71400 1 0 $X=75300 $Y=67220
X1531 2 4 372 332 335 NA2JIX1 $T=76020 33600 0 0 $X=75720 $Y=33340
X1532 2 4 328 330 349 NA2JIX1 $T=76440 63840 1 0 $X=76140 $Y=59660
X1533 2 4 347 338 343 NA2JIX1 $T=76860 33600 1 0 $X=76560 $Y=29420
X1534 2 4 361 384 344 NA2JIX1 $T=82740 71400 0 0 $X=82440 $Y=71140
X1535 2 4 383 406 392 NA2JIX1 $T=86940 63840 1 180 $X=84960 $Y=63580
X1536 2 4 409 412 407 NA2JIX1 $T=89880 33600 0 180 $X=87900 $Y=29420
X1537 2 4 385 417 398 NA2JIX1 $T=89880 41160 1 0 $X=89580 $Y=36980
X1538 2 4 394 429 438 NA2JIX1 $T=91560 56280 1 0 $X=91260 $Y=52100
X1539 2 4 485 442 450 NA2JIX1 $T=93660 26040 1 0 $X=93360 $Y=21860
X1540 2 4 457 462 464 NA2JIX1 $T=97440 63840 0 0 $X=97140 $Y=63580
X1541 2 4 435 501 481 NA2JIX1 $T=102060 48720 0 0 $X=101760 $Y=48460
X1542 2 4 481 500 475 NA2JIX1 $T=102060 56280 1 0 $X=101760 $Y=52100
X1543 2 4 475 505 497 NA2JIX1 $T=103320 71400 1 0 $X=103020 $Y=67220
X1544 2 4 516 510 514 NA2JIX1 $T=110880 26040 1 0 $X=110580 $Y=21860
X1545 2 236 4 208 215 EO2JIX1 $T=58380 33600 0 0 $X=58080 $Y=33340
X1546 2 226 4 193 207 EO2JIX1 $T=58380 71400 0 0 $X=58080 $Y=71140
X1547 2 253 4 228 238 EO2JIX1 $T=61740 41160 0 0 $X=61440 $Y=40900
X1548 2 262 4 187 200 EO2JIX1 $T=64260 48720 0 0 $X=63960 $Y=48460
X1549 2 267 4 190 210 EO2JIX1 $T=64260 63840 0 0 $X=63960 $Y=63580
X1550 2 276 4 255 248 EO2JIX1 $T=65100 33600 0 0 $X=64800 $Y=33340
X1551 2 264 4 262 259 EO2JIX1 $T=66360 48720 1 0 $X=66060 $Y=44540
X1552 2 284 4 264 269 EO2JIX1 $T=66360 63840 1 0 $X=66060 $Y=59660
X1553 2 269 4 267 242 EO2JIX1 $T=67620 63840 0 0 $X=67320 $Y=63580
X1554 2 277 4 265 226 EO2JIX1 $T=67620 71400 0 0 $X=67320 $Y=71140
X1555 2 297 4 312 237 EO2JIX1 $T=68460 33600 1 0 $X=68160 $Y=29420
X1556 2 298 4 253 236 EO2JIX1 $T=68460 41160 0 0 $X=68160 $Y=40900
X1557 2 308 4 284 294 EO2JIX1 $T=69720 63840 1 0 $X=69420 $Y=59660
X1558 2 336 4 276 297 EO2JIX1 $T=71820 41160 1 0 $X=71520 $Y=36980
X1559 2 352 4 298 307 EO2JIX1 $T=73920 48720 1 0 $X=73620 $Y=44540
X1560 2 355 4 322 336 EO2JIX1 $T=75600 41160 1 0 $X=75300 $Y=36980
X1561 2 306 4 329 345 EO2JIX1 $T=77280 63840 0 0 $X=76980 $Y=63580
X1562 2 369 4 277 306 EO2JIX1 $T=77280 71400 1 0 $X=76980 $Y=67220
X1563 2 345 4 327 293 EO2JIX1 $T=78120 56280 0 0 $X=77820 $Y=56020
X1564 2 380 4 16 369 EO2JIX1 $T=80640 71400 1 0 $X=80340 $Y=67220
X1565 2 391 4 363 372 EO2JIX1 $T=81060 33600 0 0 $X=80760 $Y=33340
X1566 2 386 4 280 374 EO2JIX1 $T=81480 48720 0 0 $X=81180 $Y=48460
X1567 2 348 4 386 394 EO2JIX1 $T=84840 48720 0 0 $X=84540 $Y=48460
X1568 2 404 4 398 401 EO2JIX1 $T=86520 26040 0 0 $X=86220 $Y=25780
X1569 2 421 4 404 409 EO2JIX1 $T=87780 26040 1 0 $X=87480 $Y=21860
X1570 2 366 4 425 451 EO2JIX1 $T=91140 56280 1 180 $X=87480 $Y=56020
X1571 2 400 4 422 443 EO2JIX1 $T=91560 86520 0 180 $X=87900 $Y=82340
X1572 2 374 4 458 435 EO2JIX1 $T=91560 41160 0 0 $X=91260 $Y=40900
X1573 2 377 4 455 440 EO2JIX1 $T=95340 63840 1 180 $X=91680 $Y=63580
X1574 2 389 4 434 461 EO2JIX1 $T=92820 71400 0 0 $X=92520 $Y=71140
X1575 2 451 4 430 459 EO2JIX1 $T=98280 56280 1 180 $X=94620 $Y=56020
X1576 2 459 4 473 475 EO2JIX1 $T=101220 56280 0 180 $X=97560 $Y=52100
X1577 2 464 4 476 472 EO2JIX1 $T=102480 71400 1 180 $X=98820 $Y=71140
X1578 2 476 4 512 507 EO2JIX1 $T=110460 71400 0 0 $X=110160 $Y=71140
X1587 2 4 61 6 INVJIX1 $T=37800 56280 1 0 $X=37500 $Y=52100
X1588 2 4 250 193 INVJIX1 $T=61740 71400 0 0 $X=61440 $Y=71140
X1589 2 4 257 207 INVJIX1 $T=63000 71400 0 0 $X=62700 $Y=71140
X1590 2 4 285 277 INVJIX1 $T=68460 71400 1 0 $X=68160 $Y=67220
X1591 2 4 265 315 INVJIX1 $T=70980 71400 0 0 $X=70680 $Y=71140
X1592 2 4 313 306 INVJIX1 $T=72240 71400 1 0 $X=71940 $Y=67220
X1593 2 4 330 327 INVJIX1 $T=75180 63840 1 0 $X=74880 $Y=59660
X1594 2 4 349 293 INVJIX1 $T=78960 63840 1 0 $X=78660 $Y=59660
X1595 2 4 329 361 INVJIX1 $T=81060 63840 0 0 $X=80760 $Y=63580
X1596 2 4 507 502 INVJIX1 $T=108360 71400 1 0 $X=108060 $Y=67220
X1597 2 4 512 504 INVJIX1 $T=109620 71400 1 0 $X=109320 $Y=67220
X1598 2 4 511 414 INVJIX1 $T=111300 86520 0 180 $X=109740 $Y=82340
X1599 2 4 DECAP10JI $T=26040 56280 0 0 $X=25740 $Y=56020
X1600 2 4 DECAP10JI $T=45360 109200 1 180 $X=40860 $Y=108940
X1601 2 4 DECAP10JI $T=47040 26040 1 180 $X=42540 $Y=25780
X1602 2 4 DECAP10JI $T=50820 109200 0 0 $X=50520 $Y=108940
X1603 2 4 DECAP10JI $T=54600 26040 0 0 $X=54300 $Y=25780
X1604 2 4 DECAP10JI $T=62580 48720 1 180 $X=58080 $Y=48460
X1605 2 4 DECAP10JI $T=64680 26040 0 0 $X=64380 $Y=25780
X1606 2 4 DECAP10JI $T=69720 94080 0 0 $X=69420 $Y=93820
X1607 2 4 DECAP10JI $T=73920 109200 0 0 $X=73620 $Y=108940
X1608 2 4 DECAP10JI $T=83160 41160 0 180 $X=78660 $Y=36980
X1609 2 4 DECAP10JI $T=79380 86520 1 0 $X=79080 $Y=82340
X1610 2 4 DECAP10JI $T=104580 94080 1 0 $X=104280 $Y=89900
X1611 2 4 DECAP10JI $T=108360 109200 0 0 $X=108060 $Y=108940
X1612 2 4 DECAP10JI $T=108780 63840 0 0 $X=108480 $Y=63580
X1613 2 4 DECAP10JI $T=108780 94080 1 0 $X=108480 $Y=89900
X1614 2 4 DECAP10JI $T=109620 48720 0 0 $X=109320 $Y=48460
X1615 185 2 4 160 192 NA2JIX0 $T=51660 86520 1 0 $X=51360 $Y=82340
X1616 229 2 4 164 158 NA2JIX0 $T=55440 33600 1 0 $X=55140 $Y=29420
X1617 245 2 4 166 159 NA2JIX0 $T=56700 41160 1 0 $X=56400 $Y=36980
X1618 240 2 4 187 200 NA2JIX0 $T=61320 48720 1 0 $X=61020 $Y=44540
X1619 251 2 4 246 248 NA2JIX0 $T=63420 33600 0 0 $X=63120 $Y=33340
X1620 256 2 4 190 210 NA2JIX0 $T=63840 63840 1 0 $X=63540 $Y=59660
X1621 247 2 4 243 192 NA2JIX0 $T=64260 86520 1 0 $X=63960 $Y=82340
X1622 316 2 4 264 269 NA2JIX0 $T=68040 56280 0 0 $X=67740 $Y=56020
X1623 295 2 4 283 305 NA2JIX0 $T=69720 33600 0 0 $X=69420 $Y=33340
X1624 332 2 4 276 297 NA2JIX0 $T=72660 33600 0 0 $X=72360 $Y=33340
X1625 317 2 4 177 289 NA2JIX0 $T=73500 94080 1 0 $X=73200 $Y=89900
X1626 343 2 4 324 237 NA2JIX0 $T=75180 33600 1 0 $X=74880 $Y=29420
X1627 338 2 4 290 311 NA2JIX0 $T=78960 26040 1 180 $X=76980 $Y=25780
X1628 370 2 4 348 355 NA2JIX0 $T=81060 41160 0 0 $X=80760 $Y=40900
X1629 387 2 4 375 372 NA2JIX0 $T=83160 33600 1 0 $X=82860 $Y=29420
X1630 395 2 4 400 13 NA2JIX0 $T=84840 78960 1 0 $X=84540 $Y=74780
X1631 402 2 4 389 380 NA2JIX0 $T=85680 71400 1 0 $X=85380 $Y=67220
X1632 403 2 4 280 374 NA2JIX0 $T=86100 48720 1 0 $X=85800 $Y=44540
X1633 410 2 4 403 405 NA2JIX0 $T=86940 41160 0 0 $X=86640 $Y=40900
X1634 417 2 4 408 410 NA2JIX0 $T=88200 41160 1 0 $X=87900 $Y=36980
X1635 412 2 4 385 391 NA2JIX0 $T=89880 33600 0 0 $X=89580 $Y=33340
X1636 450 2 4 409 428 NA2JIX0 $T=91140 26040 1 0 $X=90840 $Y=21860
X1637 442 2 4 398 401 NA2JIX0 $T=92400 26040 0 0 $X=92100 $Y=25780
X1638 429 2 4 430 459 NA2JIX0 $T=95340 56280 1 0 $X=95040 $Y=52100
X1639 465 2 4 460 463 NA2JIX0 $T=97020 78960 0 0 $X=96720 $Y=78700
X1640 488 2 4 507 512 NA2JIX0 $T=108780 71400 0 0 $X=108480 $Y=71140
X1641 4 2 217 191 234 ICV_4 $T=62160 26040 0 0 $X=61860 $Y=25780
X1642 4 2 253 236 271 ICV_4 $T=65100 41160 0 0 $X=64800 $Y=40900
X1643 4 2 377 308 371 ICV_4 $T=80220 63840 1 0 $X=79920 $Y=59660
X1644 4 2 432 421 466 ICV_4 $T=95340 26040 1 0 $X=95040 $Y=21860
X1645 4 2 488 472 497 ICV_4 $T=102480 71400 0 0 $X=102180 $Y=71140
X1646 4 2 489 490 501 ICV_4 $T=103740 48720 0 0 $X=103440 $Y=48460
X1647 4 2 502 504 505 ICV_4 $T=105000 71400 1 0 $X=104700 $Y=67220
X1648 4 2 508 513 514 ICV_4 $T=109620 26040 0 0 $X=109320 $Y=25780
X1666 2 208 4 164 158 EO2JIX0 $T=55020 33600 0 0 $X=54720 $Y=33340
X1667 2 228 4 166 159 EO2JIX0 $T=58380 41160 0 0 $X=58080 $Y=40900
X1668 2 255 4 217 191 EO2JIX0 $T=65100 33600 1 0 $X=64800 $Y=29420
X1669 2 312 4 290 311 EO2JIX0 $T=71820 33600 1 0 $X=71520 $Y=29420
X1670 2 363 4 241 347 EO2JIX0 $T=77700 33600 0 0 $X=77400 $Y=33340
X1671 2 373 4 348 355 EO2JIX0 $T=78960 48720 1 0 $X=78660 $Y=44540
X1672 2 397 4 385 391 EO2JIX0 $T=84420 33600 0 0 $X=84120 $Y=33340
X1673 2 431 4 381 397 EO2JIX0 $T=84420 41160 1 0 $X=84120 $Y=36980
X1674 2 418 4 400 13 EO2JIX0 $T=86520 78960 1 0 $X=86220 $Y=74780
X1675 2 458 4 453 452 EO2JIX0 $T=94920 41160 0 0 $X=94620 $Y=40900
X1676 2 493 4 474 485 EO2JIX0 $T=102060 26040 1 0 $X=101760 $Y=21860
X1677 2 494 4 493 513 EO2JIX0 $T=104160 26040 0 0 $X=103860 $Y=25780
X1678 2 473 4 489 490 EO2JIX0 $T=109200 56280 1 0 $X=108900 $Y=52100
X1679 4 2 48 54 6 61 72 ICV_6 $T=22260 78960 0 0 $X=21960 $Y=78700
X1680 4 2 80 76 6 61 84 ICV_6 $T=25200 48720 0 0 $X=24900 $Y=48460
X1681 4 2 81 86 6 61 71 ICV_6 $T=25620 78960 0 0 $X=25320 $Y=78700
X1682 4 2 65 90 6 61 93 ICV_6 $T=26040 26040 0 0 $X=25740 $Y=25780
X1683 4 2 100 103 6 61 109 ICV_6 $T=31920 78960 0 0 $X=31620 $Y=78700
X1684 4 2 124 125 6 61 132 ICV_6 $T=35280 78960 1 0 $X=34980 $Y=74780
X1685 4 2 122 129 6 61 112 ICV_6 $T=36540 33600 0 0 $X=36240 $Y=33340
X1686 4 2 110 150 6 61 111 ICV_6 $T=39480 26040 0 0 $X=39180 $Y=25780
X1687 4 2 174 166 181 177 531 ICV_6 $T=47040 41160 1 0 $X=46740 $Y=36980
X1688 4 2 176 183 6 61 161 ICV_6 $T=47460 109200 0 0 $X=47160 $Y=108940
X1689 4 2 157 190 181 177 532 ICV_6 $T=50820 63840 1 0 $X=50520 $Y=59660
X1690 4 2 163 191 181 177 533 ICV_6 $T=51240 26040 0 0 $X=50940 $Y=25780
X1691 4 2 196 200 181 177 534 ICV_6 $T=55440 48720 1 0 $X=55140 $Y=44540
X1692 4 2 201 210 181 177 535 ICV_6 $T=57540 63840 1 0 $X=57240 $Y=59660
X1693 4 2 204 217 181 177 536 ICV_6 $T=58800 26040 0 0 $X=58500 $Y=25780
X1694 4 2 266 268 6 61 278 ICV_6 $T=66360 109200 0 0 $X=66060 $Y=108940
X1695 4 2 286 293 181 177 537 ICV_6 $T=69720 48720 1 0 $X=69420 $Y=44540
X1696 4 2 274 303 181 177 538 ICV_6 $T=70980 78960 1 0 $X=70680 $Y=74780
X1697 4 2 346 311 181 177 539 ICV_6 $T=80220 26040 0 0 $X=79920 $Y=25780
X1698 4 2 411 416 6 61 333 ICV_6 $T=88200 101640 0 0 $X=87900 $Y=101380
X1699 4 2 408 467 435 452 453 ICV_6 $T=98280 41160 0 0 $X=97980 $Y=40900
X1700 4 2 447 470 6 61 326 ICV_6 $T=98700 109200 0 0 $X=98400 $Y=108940
X1701 4 2 495 453 181 177 540 ICV_6 $T=104160 33600 0 0 $X=103860 $Y=33340
X1702 4 2 492 502 181 177 541 ICV_6 $T=105000 71400 0 0 $X=104700 $Y=71140
X1703 4 2 483 460 181 177 542 ICV_6 $T=105000 86520 1 0 $X=104700 $Y=82340
X1704 4 2 482 504 181 177 543 ICV_6 $T=105420 63840 0 0 $X=105120 $Y=63580
X1705 4 2 491 490 181 177 544 ICV_6 $T=105840 56280 1 0 $X=105540 $Y=52100
X1706 4 2 496 489 181 177 545 ICV_6 $T=106260 48720 0 0 $X=105960 $Y=48460
X1707 4 2 484 509 6 61 320 ICV_6 $T=108360 101640 0 0 $X=108060 $Y=101380
X1809 232 2 4 160 194 NA2I1JIX0 $T=60060 86520 0 0 $X=59760 $Y=86260
X1810 205 2 4 243 239 NA2I1JIX0 $T=66360 86520 1 0 $X=66060 $Y=82340
X1811 508 2 4 474 506 NA2I1JIX0 $T=107520 26040 0 0 $X=107220 $Y=25780
X1812 510 2 4 506 474 NA2I1JIX0 $T=107940 26040 1 0 $X=107640 $Y=21860
X1813 2 188 4 107 INVJIX0 $T=47040 86520 1 0 $X=46740 $Y=82340
X1814 2 181 4 177 INVJIX0 $T=57120 48720 0 0 $X=56820 $Y=48460
X1815 2 95 4 225 INVJIX0 $T=59640 78960 0 0 $X=59340 $Y=78700
X1816 2 272 4 264 INVJIX0 $T=66780 56280 0 0 $X=66480 $Y=56020
X1817 2 288 4 194 INVJIX0 $T=67200 86520 0 0 $X=66900 $Y=86260
X1818 2 279 4 253 INVJIX0 $T=68040 41160 1 0 $X=67740 $Y=36980
X1819 2 283 4 276 INVJIX0 $T=68460 33600 0 0 $X=68160 $Y=33340
X1820 2 305 4 297 INVJIX0 $T=71400 33600 0 0 $X=71100 $Y=33340
X1821 2 289 4 239 INVJIX0 $T=72240 94080 1 0 $X=71940 $Y=89900
X1822 2 376 4 366 INVJIX0 $T=81900 56280 0 0 $X=81600 $Y=56020
X1823 2 399 4 352 INVJIX0 $T=85680 56280 0 0 $X=85380 $Y=56020
X1824 2 471 4 414 INVJIX0 $T=99120 56280 0 0 $X=98820 $Y=56020
X1825 2 506 4 485 INVJIX0 $T=106260 26040 1 0 $X=105960 $Y=21860
X1834 2 211 4 164 158 OR2JIX0 $T=57120 33600 1 0 $X=56820 $Y=29420
X1835 2 223 4 166 159 OR2JIX0 $T=59220 41160 1 0 $X=58920 $Y=36980
X1836 2 254 4 187 200 OR2JIX0 $T=59220 48720 1 0 $X=58920 $Y=44540
X1837 2 224 4 190 210 OR2JIX0 $T=59220 63840 0 0 $X=58920 $Y=63580
X1838 2 246 4 217 191 OR2JIX0 $T=63000 33600 1 0 $X=62700 $Y=29420
X1839 2 324 4 290 311 OR2JIX0 $T=74340 26040 0 0 $X=74040 $Y=25780
X1840 2 375 4 241 347 OR2JIX0 $T=81060 33600 1 0 $X=80760 $Y=29420
X1841 2 392 4 308 377 OR2JIX0 $T=82320 63840 0 0 $X=82020 $Y=63580
X1842 2 428 4 401 398 OR2JIX0 $T=90300 26040 0 0 $X=90000 $Y=25780
X1843 2 467 4 453 452 OR2JIX0 $T=101640 41160 0 180 $X=99240 $Y=36980
X1844 2 500 4 489 490 OR2JIX0 $T=103740 56280 1 0 $X=103440 $Y=52100
X1851 2 4 69 38 62 43 91 121 SDFRRQJIX1 $T=22260 63840 0 0 $X=21960 $Y=63580
X1852 2 4 72 38 71 48 91 121 SDFRRQJIX1 $T=23100 78960 1 0 $X=22800 $Y=74780
X1853 2 4 78 38 72 55 91 121 SDFRRQJIX1 $T=23100 86520 1 0 $X=22800 $Y=82340
X1854 2 4 84 38 77 80 91 121 SDFRRQJIX1 $T=23520 56280 1 0 $X=23220 $Y=52100
X1855 2 4 71 38 70 81 91 121 SDFRRQJIX1 $T=23520 71400 0 0 $X=23220 $Y=71140
X1856 2 4 88 38 78 82 91 121 SDFRRQJIX1 $T=23520 94080 1 0 $X=23220 $Y=89900
X1857 2 4 67 38 84 83 91 121 SDFRRQJIX1 $T=25200 48720 1 0 $X=24900 $Y=44540
X1858 2 4 77 38 85 53 91 121 SDFRRQJIX1 $T=25200 63840 1 0 $X=24900 $Y=59660
X1859 2 4 70 38 69 40 91 121 SDFRRQJIX1 $T=25200 71400 1 0 $X=24900 $Y=67220
X1860 2 4 73 38 88 41 91 121 SDFRRQJIX1 $T=25200 94080 0 0 $X=24900 $Y=93820
X1861 2 4 74 38 89 42 91 121 SDFRRQJIX1 $T=25200 101640 1 0 $X=24900 $Y=97460
X1862 2 4 132 38 126 124 91 121 SDFRRQJIX1 $T=35280 71400 0 0 $X=34980 $Y=71140
X1863 2 4 119 38 132 102 91 121 SDFRRQJIX1 $T=36120 63840 0 0 $X=35820 $Y=63580
X1864 2 4 101 38 133 94 91 121 SDFRRQJIX1 $T=36120 86520 0 0 $X=35820 $Y=86260
X1865 2 4 126 38 138 139 91 121 SDFRRQJIX1 $T=36960 71400 1 0 $X=36660 $Y=67220
X1866 2 4 85 38 119 97 91 121 SDFRRQJIX1 $T=38640 63840 1 0 $X=38340 $Y=59660
X1867 2 4 164 38 159 165 91 121 SDFRRQJIX1 $T=44100 33600 0 0 $X=43800 $Y=33340
X1868 2 4 177 38 160 169 91 121 SDFRRQJIX1 $T=44100 78960 1 0 $X=43800 $Y=74780
X1869 2 4 170 36 161 171 91 121 SDFRRQJIX1 $T=44100 101640 0 0 $X=43800 $Y=101380
X1870 2 4 158 38 164 172 91 121 SDFRRQJIX1 $T=44520 33600 1 0 $X=44220 $Y=29420
X1871 2 4 159 38 166 173 91 121 SDFRRQJIX1 $T=44520 41160 0 0 $X=44220 $Y=40900
X1872 2 4 166 38 167 174 91 121 SDFRRQJIX1 $T=44520 48720 1 0 $X=44220 $Y=44540
X1873 2 4 162 36 170 175 91 121 SDFRRQJIX1 $T=44520 94080 0 0 $X=44220 $Y=93820
X1874 2 4 239 38 195 7 91 121 SDFRRQJIX1 $T=56700 94080 1 0 $X=56400 $Y=89900
X1875 2 4 243 38 209 221 91 121 SDFRRQJIX1 $T=58800 78960 1 0 $X=58500 $Y=74780
X1876 2 4 209 36 213 222 91 121 SDFRRQJIX1 $T=58800 94080 0 0 $X=58500 $Y=93820
X1877 2 4 194 38 239 10 91 121 SDFRRQJIX1 $T=68460 86520 1 0 $X=68160 $Y=82340
X1878 2 4 292 36 350 353 91 121 SDFRRQJIX1 $T=77700 94080 0 0 $X=77400 $Y=93820
X1879 2 4 304 36 292 364 91 121 SDFRRQJIX1 $T=78960 101640 1 0 $X=78660 $Y=97460
X1880 2 4 326 36 368 447 91 121 SDFRRQJIX1 $T=91980 101640 0 0 $X=91680 $Y=101380
X1881 2 4 432 36 452 456 91 471 SDFRRQJIX1 $T=93240 33600 0 0 $X=92940 $Y=33340
X1882 2 4 320 36 358 484 91 121 SDFRRQJIX1 $T=100800 94080 0 0 $X=100500 $Y=93820
X1883 2 4 490 36 486 491 91 511 SDFRRQJIX1 $T=101640 56280 0 0 $X=101340 $Y=56020
X1884 2 4 453 36 489 495 91 511 SDFRRQJIX1 $T=102060 41160 0 0 $X=101760 $Y=40900
X1885 2 4 452 36 453 499 91 511 SDFRRQJIX1 $T=102900 41160 1 0 $X=102600 $Y=36980
X1886 2 190 4 182 38 156 157 91 121 SDFRRSJIX1 $T=42420 56280 0 0 $X=42120 $Y=56020
X1887 2 187 4 167 38 146 168 91 121 SDFRRSJIX1 $T=44100 48720 0 0 $X=43800 $Y=48460
X1888 2 193 4 138 38 177 179 91 121 SDFRRSJIX1 $T=46200 71400 0 0 $X=45900 $Y=71140
X1889 2 207 4 62 38 182 184 91 121 SDFRRSJIX1 $T=47040 63840 0 0 $X=46740 $Y=63580
X1890 2 200 4 198 38 197 196 91 121 SDFRRSJIX1 $T=54600 56280 1 0 $X=54300 $Y=52100
X1891 2 210 4 156 38 198 201 91 121 SDFRRSJIX1 $T=54600 56280 0 0 $X=54300 $Y=56020
X1892 2 303 4 341 38 243 274 91 121 SDFRRSJIX1 $T=65940 78960 0 0 $X=65640 $Y=78700
X1893 2 293 4 281 38 280 286 91 121 SDFRRSJIX1 $T=67620 48720 0 0 $X=67320 $Y=48460
X1894 2 327 4 197 38 281 287 91 121 SDFRRSJIX1 $T=67620 56280 1 0 $X=67320 $Y=52100
X1895 2 309 4 357 38 341 356 91 121 SDFRRSJIX1 $T=78120 78960 0 0 $X=77820 $Y=78700
X1896 2 384 4 367 36 357 362 91 121 SDFRRSJIX1 $T=78540 86520 0 0 $X=78240 $Y=86260
X1897 2 344 4 350 36 367 339 91 121 SDFRRSJIX1 $T=80220 94080 1 0 $X=79920 $Y=89900
X1898 2 443 4 446 36 333 420 91 121 SDFRRSJIX1 $T=88620 94080 0 0 $X=88320 $Y=93820
X1899 2 422 4 480 36 446 448 91 121 SDFRRSJIX1 $T=92400 94080 1 0 $X=92100 $Y=89900
X1900 2 504 4 486 36 462 482 91 511 SDFRRSJIX1 $T=100800 63840 1 0 $X=100500 $Y=59660
X1901 2 460 4 487 36 479 483 91 511 SDFRRSJIX1 $T=100800 78960 0 0 $X=100500 $Y=78700
X1902 2 463 4 479 36 480 478 91 511 SDFRRSJIX1 $T=100800 86520 0 0 $X=100500 $Y=86260
X1903 2 502 4 441 36 487 492 91 511 SDFRRSJIX1 $T=101640 78960 1 0 $X=101340 $Y=74780
X1904 4 2 51 56 6 61 60 ICV_10 $T=22260 26040 0 0 $X=21960 $Y=25780
X1905 4 2 52 57 6 61 66 ICV_10 $T=22260 33600 0 0 $X=21960 $Y=33340
X1906 4 2 53 58 6 61 77 ICV_10 $T=22260 56280 0 0 $X=21960 $Y=56020
X1907 4 2 55 59 6 61 78 ICV_10 $T=22260 86520 0 0 $X=21960 $Y=86260
X1908 4 2 75 92 6 61 63 ICV_10 $T=27300 109200 0 0 $X=27000 $Y=108940
X1909 4 2 94 96 6 61 101 ICV_10 $T=28980 86520 0 0 $X=28680 $Y=86260
X1910 4 2 97 99 6 61 85 ICV_10 $T=30240 56280 0 0 $X=29940 $Y=56020
X1911 4 2 115 35 6 61 116 ICV_10 $T=35700 26040 0 0 $X=35400 $Y=25780
X1912 4 2 117 130 6 61 146 ICV_10 $T=36120 48720 1 0 $X=35820 $Y=44540
X1913 4 2 273 290 181 177 546 ICV_10 $T=68880 26040 0 0 $X=68580 $Y=25780
X1914 4 2 423 449 6 61 368 ICV_10 $T=92820 109200 0 0 $X=92520 $Y=108940
X1915 4 2 478 463 181 177 547 ICV_10 $T=101220 86520 1 0 $X=100920 $Y=82340
X1916 381 2 4 370 19 390 ON21JIX1 $T=83160 41160 0 0 $X=82860 $Y=40900
X1917 406 2 4 402 395 393 ON21JIX1 $T=87360 71400 1 0 $X=87060 $Y=67220
X1918 407 2 4 381 391 385 ON21JIX1 $T=87780 33600 0 0 $X=87480 $Y=33340
X1919 405 2 4 394 280 374 ON21JIX1 $T=88620 48720 1 0 $X=88320 $Y=44540
X1920 438 2 4 425 430 459 ON21JIX1 $T=93240 56280 1 0 $X=92940 $Y=52100
X1921 425 2 4 457 455 468 ON21JIX1 $T=95340 63840 0 0 $X=95040 $Y=63580
X1922 513 2 4 466 444 469 ON21JIX1 $T=103320 26040 1 180 $X=100920 $Y=25780
X1923 4 437 2 373 19 EN2JIX0 $T=82740 48720 1 0 $X=82440 $Y=44540
X1924 4 440 2 464 462 EN2JIX0 $T=100800 63840 0 0 $X=100500 $Y=63580
X1936 2 390 4 348 355 NO2JIX1 $T=79380 41160 0 0 $X=79080 $Y=40900
X1937 2 393 4 380 389 NO2JIX1 $T=84000 71400 1 0 $X=83700 $Y=67220
X1938 2 469 4 432 421 NO2JIX1 $T=98280 26040 1 0 $X=97980 $Y=21860
X1939 2 468 4 462 464 NO2JIX1 $T=99120 63840 0 0 $X=98820 $Y=63580
X1940 4 2 229 235 237 ICV_12 $T=60900 33600 1 0 $X=60600 $Y=29420
X1941 4 2 223 238 252 ICV_12 $T=61320 41160 1 0 $X=61020 $Y=36980
X1942 4 2 245 252 248 ICV_12 $T=63420 41160 1 0 $X=63120 $Y=36980
X1943 4 2 314 323 242 ICV_12 $T=72660 63840 0 0 $X=72360 $Y=63580
X1944 4 2 327 293 314 ICV_12 $T=73080 63840 1 0 $X=72780 $Y=59660
X1945 4 2 271 321 322 ICV_12 $T=73500 41160 0 0 $X=73200 $Y=40900
X1946 4 2 328 329 323 ICV_12 $T=74760 63840 0 0 $X=74460 $Y=63580
X1947 4 2 371 383 382 ICV_12 $T=82740 63840 1 0 $X=82440 $Y=59660
X1948 4 2 376 399 379 ICV_12 $T=83160 56280 0 0 $X=82860 $Y=56020
X1949 4 2 427 431 444 ICV_12 $T=96180 41160 1 0 $X=95880 $Y=36980
X1950 4 2 434 461 455 ICV_12 $T=96180 71400 0 0 $X=95880 $Y=71140
X1951 4 2 465 20 472 ICV_12 $T=98700 78960 0 0 $X=98400 $Y=78700
X1960 2 151 4 203 160 NO2I1JIX0 $T=50400 86520 0 0 $X=50100 $Y=86260
X1961 2 131 4 214 160 NO2I1JIX0 $T=53760 86520 1 0 $X=53460 $Y=82340
X1962 2 203 4 258 194 NO2I1JIX0 $T=55020 86520 0 0 $X=54720 $Y=86260
X1963 2 106 4 258 232 NO2I1JIX0 $T=62580 86520 0 0 $X=62280 $Y=86260
X1964 2 413 4 419 414 NO2I1JIX0 $T=90720 63840 1 180 $X=88320 $Y=63580
X1965 2 426 4 415 414 NO2I1JIX0 $T=89460 71400 1 0 $X=89160 $Y=67220
X1966 2 445 4 418 414 NO2I1JIX0 $T=89880 78960 1 0 $X=89580 $Y=74780
X1967 2 433 4 424 414 NO2I1JIX0 $T=91980 56280 0 0 $X=91680 $Y=56020
X1968 2 456 4 444 439 NO2I1JIX0 $T=94080 41160 1 0 $X=93780 $Y=36980
X1969 2 4 415 395 389 380 EN3JIX0 $T=86520 71400 0 0 $X=86220 $Y=71140
X1970 2 4 436 432 421 444 EN3JIX0 $T=94080 26040 0 0 $X=93780 $Y=25780
X1971 2 153 4 203 160 AND2JIX0 $T=52500 86520 0 0 $X=52200 $Y=86260
X1972 2 136 4 214 160 AND2JIX0 $T=55860 86520 1 0 $X=55560 $Y=82340
X1973 2 360 4 347 241 AND2JIX0 $T=78960 33600 1 0 $X=78660 $Y=29420
X1974 2 388 4 352 366 AND2JIX0 $T=80220 56280 1 0 $X=79920 $Y=52100
X1975 2 454 4 443 422 AND2JIX0 $T=93240 86520 1 0 $X=92940 $Y=82340
X1976 2 4 280 36 430 433 91 SDFRQJIX1 $T=90720 48720 0 0 $X=90420 $Y=48460
X1977 2 4 430 36 427 413 91 SDFRQJIX1 $T=91140 63840 1 0 $X=90840 $Y=59660
X1978 2 4 434 36 441 445 91 SDFRQJIX1 $T=91980 78960 1 0 $X=91680 $Y=74780
X1979 2 4 462 36 434 426 91 SDFRQJIX1 $T=92400 71400 1 0 $X=92100 $Y=67220
X1980 2 214 4 194 205 NO2JIX0 $T=57960 86520 1 0 $X=57660 $Y=82340
X1981 2 107 4 232 205 NO2JIX0 $T=59640 86520 1 0 $X=59340 $Y=82340
X1982 2 258 4 239 243 NO2JIX0 $T=65100 86520 0 0 $X=64800 $Y=86260
X1983 2 319 4 303 309 NO2JIX0 $T=75180 78960 1 0 $X=74880 $Y=74780
X1984 2 365 4 384 344 NO2JIX0 $T=84420 71400 0 0 $X=84120 $Y=71140
X1985 2 439 4 427 431 NO2JIX0 $T=91980 41160 1 0 $X=91680 $Y=36980
X1986 4 2 38 60 65 91 121 93 38 93 110 121 111 ICV_14 $T=22260 26040 1 0 $X=21960 $Y=21860
X1987 4 2 38 63 64 91 121 89 36 74 104 121 113 ICV_14 $T=22260 101640 0 0 $X=21960 $Y=101380
X1988 4 2 38 66 51 91 121 60 38 111 115 121 116 ICV_14 $T=22680 33600 1 0 $X=22380 $Y=29420
X1989 4 2 38 67 39 91 121 68 38 112 117 121 146 ICV_14 $T=22680 41160 0 0 $X=22380 $Y=40900
X1990 4 2 36 34 75 91 121 63 36 113 120 121 152 ICV_14 $T=22680 109200 1 0 $X=22380 $Y=105020
X1991 4 2 38 68 52 91 121 66 38 116 122 121 112 ICV_14 $T=23100 41160 1 0 $X=22800 $Y=36980
X1992 4 2 38 73 127 91 121 133 36 162 178 121 195 ICV_14 $T=34860 94080 1 0 $X=34560 $Y=89900
X1993 4 2 38 101 100 91 121 109 38 109 180 121 160 ICV_14 $T=35280 78960 0 0 $X=34980 $Y=78700
X1994 4 2 38 158 163 91 121 191 38 191 204 121 217 ICV_14 $T=44100 26040 1 0 $X=43800 $Y=21860
X1995 4 2 36 152 176 91 121 161 36 202 206 121 216 ICV_14 $T=44520 109200 1 0 $X=44220 $Y=105020
X1996 4 2 36 216 218 91 121 213 36 194 266 121 278 ICV_14 $T=57960 101640 0 0 $X=57660 $Y=101380
X1997 4 2 38 217 273 91 121 290 38 290 346 121 311 ICV_14 $T=65940 26040 1 0 $X=65640 $Y=21860
X1998 4 2 36 278 282 91 121 270 36 270 354 121 202 ICV_14 $T=67200 109200 1 0 $X=66900 $Y=105020
X1999 4 2 36 304 423 91 121 368 36 326 477 121 310 ICV_14 $T=89040 109200 1 0 $X=88740 $Y=105020
X2000 4 2 36 311 436 91 471 474 36 474 494 471 517 ICV_14 $T=91140 33600 1 0 $X=90840 $Y=29420
X2001 4 2 36 432 437 91 471 427 36 490 496 511 489 ICV_14 $T=91140 48720 1 0 $X=90840 $Y=44540
X2002 4 2 36 320 411 91 121 333 36 310 498 121 358 ICV_14 $T=91140 101640 1 0 $X=90840 $Y=97460
X2003 2 419 4 377 308 406 EO3JIX0 $T=84840 63840 1 0 $X=84540 $Y=59660
X2004 2 424 4 366 352 382 EO3JIX0 $T=85260 56280 1 0 $X=84960 $Y=52100
X2005 2 461 4 460 463 454 EO3JIX0 $T=90720 78960 0 0 $X=90420 $Y=78700
X2006 225 2 4 205 160 194 NA3I1JIX0 $T=57120 78960 0 0 $X=56820 $Y=78700
X2007 199 2 4 232 239 243 NA3I1JIX0 $T=61740 86520 1 0 $X=61440 $Y=82340
X2008 398 2 4 408 403 405 NA3I1JIX0 $T=89040 41160 0 0 $X=88740 $Y=40900
X2009 2 4 302 236 279 NA2I1JIX1 $T=69300 41160 1 0 $X=69000 $Y=36980
X2010 2 4 299 269 272 NA2I1JIX1 $T=69720 56280 0 0 $X=69420 $Y=56020
X2011 2 4 296 285 306 NA2I1JIX1 $T=70140 71400 1 0 $X=69840 $Y=67220
X2012 2 4 334 277 313 NA2I1JIX1 $T=73500 71400 1 0 $X=73200 $Y=67220
X2013 2 4 401 360 387 NA2I1JIX1 $T=84840 33600 1 0 $X=84540 $Y=29420
X2014 2 4 DECAP25JI $T=36540 33600 1 180 $X=25740 $Y=33340
X2015 2 4 DECAP25JI $T=49560 56280 0 180 $X=38760 $Y=52100
X2016 2 4 DECAP25JI $T=82320 109200 0 0 $X=82020 $Y=108940
X2017 2 325 4 315 319 NO2I1JIX1 $T=73920 71400 0 0 $X=73620 $Y=71140
X2018 2 351 4 361 365 NO2I1JIX1 $T=80640 71400 0 0 $X=80340 $Y=71140
X2019 2 108 4 119 106 107 69 AN22JIX0 $T=36120 63840 1 0 $X=35820 $Y=59660
X2020 2 135 4 74 3 95 133 AN22JIX0 $T=36120 94080 0 0 $X=35820 $Y=93820
X2021 2 123 4 70 131 136 77 AN22JIX0 $T=36960 56280 0 0 $X=36660 $Y=56020
X2022 2 147 4 63 106 107 89 AN22JIX0 $T=37380 101640 1 0 $X=37080 $Y=97460
X2023 2 143 4 112 131 136 116 AN22JIX0 $T=39900 48720 1 0 $X=39600 $Y=44540
X2024 2 142 4 73 151 153 101 AN22JIX0 $T=40320 86520 1 0 $X=40020 $Y=82340
X2025 2 137 4 109 131 136 126 AN22JIX0 $T=41580 78960 1 0 $X=41280 $Y=74780
X2026 2 155 4 152 131 136 113 AN22JIX0 $T=42420 101640 1 0 $X=42120 $Y=97460
X2027 2 233 4 170 3 95 195 AN22JIX0 $T=53760 101640 1 0 $X=53460 $Y=97460
X2028 2 220 4 202 151 153 209 AN22JIX0 $T=56280 101640 1 0 $X=55980 $Y=97460
X2029 2 230 4 213 131 136 216 AN22JIX0 $T=58800 101640 1 0 $X=58500 $Y=97460
X2030 2 340 4 310 151 153 326 AN22JIX0 $T=72660 101640 1 0 $X=72360 $Y=97460
X2031 2 342 4 358 131 136 368 AN22JIX0 $T=79800 101640 0 0 $X=79500 $Y=101380
X2032 2 4 108 98 118 123 NA4JIX0 $T=34440 56280 0 0 $X=34140 $Y=56020
X2033 2 4 114 128 142 137 NA4JIX0 $T=36540 86520 1 0 $X=36240 $Y=82340
X2034 2 4 134 140 149 143 NA4JIX0 $T=37800 48720 0 0 $X=37500 $Y=48460
X2035 2 4 147 135 154 155 NA4JIX0 $T=39900 101640 1 0 $X=39600 $Y=97460
X2036 2 4 227 233 220 230 NA4JIX0 $T=61320 101640 1 0 $X=61020 $Y=97460
X2037 2 4 331 337 340 342 NA4JIX0 $T=76020 101640 1 0 $X=75720 $Y=97460
X2038 4 180 2 185 181 188 ON21JIX0 $T=49140 86520 1 0 $X=48840 $Y=82340
X2039 4 221 2 247 181 225 ON21JIX0 $T=64260 78960 1 180 $X=61860 $Y=78700
X2040 4 291 2 317 275 177 ON21JIX0 $T=75180 94080 1 0 $X=74880 $Y=89900
X2041 4 2 67 3 95 98 68 ICV_15 $T=28560 48720 0 0 $X=28260 $Y=48460
X2042 4 2 72 3 95 128 71 ICV_15 $T=28980 78960 0 0 $X=28680 $Y=78700
X2043 4 2 60 3 95 140 84 ICV_15 $T=31500 48720 0 0 $X=31200 $Y=48460
X2044 4 2 88 106 107 114 78 ICV_15 $T=32760 86520 0 0 $X=32460 $Y=86260
X2045 4 2 66 106 107 134 93 ICV_15 $T=34440 48720 0 0 $X=34140 $Y=48460
X2046 4 2 132 151 153 118 85 ICV_15 $T=39480 56280 0 0 $X=39180 $Y=56020
X2047 4 2 146 151 153 149 111 ICV_15 $T=40320 48720 0 0 $X=40020 $Y=48460
X2048 4 2 162 151 153 154 161 ICV_15 $T=44940 101640 1 0 $X=44640 $Y=97460
X2049 4 2 270 106 107 227 278 ICV_15 $T=66780 101640 1 0 $X=66480 $Y=97460
X2050 4 2 292 3 95 337 304 ICV_15 $T=69720 101640 1 0 $X=69420 $Y=97460
X2051 4 2 320 106 107 331 333 ICV_15 $T=73920 94080 0 0 $X=73620 $Y=93820
X2052 169 2 4 177 199 6 AO21JIX0 $T=55020 78960 1 0 $X=54720 $Y=74780
X2053 192 2 4 177 288 291 AO21JIX0 $T=68880 86520 0 0 $X=68580 $Y=86260
.ENDS
***************************************
