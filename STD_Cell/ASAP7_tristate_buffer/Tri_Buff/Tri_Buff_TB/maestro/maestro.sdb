ADE simulation setup
Run mode: Single Run, Sweeps and Corners
Tests:
  Tri-Buff_Tri_Buff_TB_1: Tri_Buff/Tri_Buff_TB/schematic, simulator spectre
