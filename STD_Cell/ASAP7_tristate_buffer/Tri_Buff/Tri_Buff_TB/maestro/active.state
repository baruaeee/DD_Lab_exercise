ADE simulation setup
Test Tri-Buff_Tri_Buff_TB_1: Tri_Buff/Tri_Buff_TB/schematic, simulator spectre
  Models: /home/bas33767/Desktop/asap7/asap7_pdk_r1p7/models/hspice/7nm_TT.pm
  Temperature: 27
  Analysis tran: stop=35n errpreset=moderate
  Signals: /out as Out, /net3 as E, /net1 as A
Run mode: Single Run, Sweeps and Corners
